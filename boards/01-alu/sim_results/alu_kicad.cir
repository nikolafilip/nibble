.title KiCad schematic
.include "/Users/nikolafilip/projects/nibble/lib/2N7000.lib"
.include "/Users/nikolafilip/projects/nibble/lib/led.lib"
.tran 2u 0.0052
C1 +5V GND 100n
C2 +5V GND 10u
R5 +5V XB0 47k
MQ9 BN1 B1 GND 2N7000
R6 +5V BN1 47k
MQ11 Net-_Q10-S_ SUBN GND 2N7000
R7 +5V XBA1 47k
MQ10 XBA1 B1 Net-_Q10-S_ 2N7000
MQ8 Net-_Q7-S_ XBB0 GND 2N7000
MQ7 XB0 XBA0 Net-_Q7-S_ 2N7000
MQ115 ZF S3 GND 2N7000
MQ114 ZF S2 GND 2N7000
MQ119 BUS0# BD0 GND 2N7000
R67 +5V BDN1 47k
MQ120 BDN1 S1 Net-_Q120-S_ 2N7000
MQ121 Net-_Q120-S_ EO GND 2N7000
MQ135 Net-_D4-K_ S0 GND 2N7000
R76 +5V Net-_D4-A_ 1k
D4 Net-_D4-A_ Net-_D4-K_ LEDRED
MQ134 Net-_D3-K_ S1 GND 2N7000
R68 +5V BD1 47k
MQ122 BD1 BDN1 GND 2N7000
MQ123 BUS1# BD1 GND 2N7000
R69 +5V BDN2 47k
MQ125 Net-_Q124-S_ EO GND 2N7000
MQ124 BDN2 S2 Net-_Q124-S_ 2N7000
R77 +5V Net-_D5-A_ 1k
D5 Net-_D5-A_ Net-_D5-K_ LEDRED
MQ136 Net-_D5-K_ CF GND 2N7000
D6 Net-_D6-A_ Net-_D6-K_ LEDRED
MQ137 Net-_D6-K_ ZF GND 2N7000
R78 +5V Net-_D6-A_ 1k
R70 +5V BD2 47k
MQ126 BD2 BDN2 GND 2N7000
MQ127 BUS2# BD2 GND 2N7000
R71 +5V BDN3 47k
MQ129 Net-_Q128-S_ EO GND 2N7000
MQ128 BDN3 S3 Net-_Q128-S_ 2N7000
R72 +5V BD3 47k
MQ130 BD3 BDN3 GND 2N7000
MQ131 BUS3# BD3 GND 2N7000
MQ116 BDN0 S0 Net-_Q116-S_ 2N7000
MQ117 Net-_Q116-S_ EO GND 2N7000
R65 +5V BDN0 47k
R66 +5V BD0 47k
MQ118 BD0 BDN0 GND 2N7000
MQ106 T3 P3 Net-_Q106-S_ 2N7000
MQ107 Net-_Q106-S_ C3 GND 2N7000
MQ110 CF C4N GND 2N7000
MQ111 C4N C4 GND 2N7000
MQ108 C4 G3 Net-_Q108-S_ 2N7000
MQ109 Net-_Q108-S_ T3 GND 2N7000
R62 +5V CF 47k
R63 +5V C4N 47k
MQ113 ZF S1 GND 2N7000
R64 +5V ZF 47k
MQ112 ZF S0 GND 2N7000
R73 +5V Net-_D1-A_ 1k
R75 +5V Net-_D3-A_ 1k
D3 Net-_D3-A_ Net-_D3-K_ LEDRED
D2 Net-_D2-A_ Net-_D2-K_ LEDRED
MQ133 Net-_D2-K_ S2 GND 2N7000
R74 +5V Net-_D2-A_ 1k
D1 Net-_D1-A_ Net-_D1-K_ LEDRED
MQ132 Net-_D1-K_ S3 GND 2N7000
R3 +5V XBA0 47k
MQ3 XBA0 B0 Net-_Q3-S_ 2N7000
MQ4 Net-_Q3-S_ SUBN GND 2N7000
MQ6 Net-_Q5-S_ SUB GND 2N7000
MQ28 XB3 XBA3 Net-_Q28-S_ 2N7000
R17 +5V XB3 47k
R4 +5V XBB0 47k
MQ5 XBB0 BN0 Net-_Q5-S_ 2N7000
MQ2 BN0 B0 GND 2N7000
R2 +5V BN0 47k
R1 +5V SUBN 47k
MQ1 SUBN SUB GND 2N7000
R15 +5V XBA3 47k
R16 +5V XBB3 47k
MQ24 XBA3 B3 Net-_Q24-S_ 2N7000
MQ25 Net-_Q24-S_ SUBN GND 2N7000
MQ27 Net-_Q26-S_ SUB GND 2N7000
MQ26 XBB3 BN3 Net-_Q26-S_ 2N7000
MQ29 Net-_Q28-S_ XBB3 GND 2N7000
R20 +5V P0_d 47k
MQ35 P0 P0_n GND 2N7000
MQ36 P0 P0_d GND 2N7000
R21 +5V P0 47k
MQ34 P0_d P0_a GND 2N7000
R18 +5V P0_n 47k
MQ30 P0_n A0 GND 2N7000
MQ31 P0_n XB0 GND 2N7000
MQ32 P0_a A0 Net-_Q32-S_ 2N7000
R19 +5V P0_a 47k
MQ33 Net-_Q32-S_ XB0 GND 2N7000
R23 +5V S0_a 47k
MQ39 S0_a P0 Net-_Q39-S_ 2N7000
MQ40 Net-_Q39-S_ SUB GND 2N7000
R24 +5V S0_d 47k
MQ41 S0_d S0_a GND 2N7000
R22 +5V S0_n 47k
R25 +5V S0 47k
MQ43 S0 S0_d GND 2N7000
MQ42 S0 S0_n GND 2N7000
R26 +5V G0 47k
MQ45 Net-_Q44-S_ XB0 GND 2N7000
MQ44 G0 A0 Net-_Q44-S_ 2N7000
MQ67 Net-_Q66-S_ C1 GND 2N7000
MQ66 T1 P1 Net-_Q66-S_ 2N7000
R37 +5V G1 47k
MQ64 G1 A1 Net-_Q64-S_ 2N7000
MQ65 Net-_Q64-S_ XB1 GND 2N7000
R38 +5V T1 47k
R36 +5V S1 47k
MQ69 Net-_Q68-S_ T1 GND 2N7000
MQ68 C2 G1 Net-_Q68-S_ 2N7000
R39 +5V C2 47k
R40 +5V P2_n 47k
MQ71 P2_n XB2 GND 2N7000
MQ70 P2_n A2 GND 2N7000
MQ93 Net-_Q92-S_ XB3 GND 2N7000
MQ92 P3_a A3 Net-_Q92-S_ 2N7000
R51 +5V P3_n 47k
R50 +5V C3 47k
MQ91 P3_n XB3 GND 2N7000
MQ90 P3_n A3 GND 2N7000
R52 +5V P3_a 47k
R53 +5V P3_d 47k
R54 +5V P3 47k
MQ95 P3 P3_n GND 2N7000
MQ96 P3 P3_d GND 2N7000
MQ94 P3_d P3_a GND 2N7000
MQ74 P2_d P2_a GND 2N7000
MQ72 P2_a A2 Net-_Q72-S_ 2N7000
MQ73 Net-_Q72-S_ XB2 GND 2N7000
MQ46 T0 P0 Net-_Q46-S_ 2N7000
MQ47 Net-_Q46-S_ SUB GND 2N7000
R41 +5V P2_a 47k
MQ49 Net-_Q48-S_ T0 GND 2N7000
R42 +5V P2_d 47k
MQ48 C1 G0 Net-_Q48-S_ 2N7000
R44 +5V S2_n 47k
R43 +5V P2 47k
MQ53 Net-_Q52-S_ XB1 GND 2N7000
MQ52 P1_a A1 Net-_Q52-S_ 2N7000
MQ54 P1_d P1_a GND 2N7000
R45 +5V S2_a 47k
MQ79 S2_a P2 Net-_Q79-S_ 2N7000
MQ51 P1_n XB1 GND 2N7000
MQ50 P1_n A1 GND 2N7000
MQ100 Net-_Q100-D_ C3 GND 2N7000
MQ99 S3_a P3 Net-_Q100-D_ 2N7000
R55 +5V S3_n 47k
MQ98 S3_n C3 GND 2N7000
MQ97 S3_n P3 GND 2N7000
R56 +5V S3_a 47k
MQ75 P2 P2_n GND 2N7000
MQ76 P2 P2_d GND 2N7000
R57 +5V S3_d 47k
MQ77 S2_n P2 GND 2N7000
MQ101 S3_d S3_a GND 2N7000
MQ102 S3 S3_n GND 2N7000
MQ103 S3 S3_d GND 2N7000
MQ80 Net-_Q79-S_ C2 GND 2N7000
R59 +5V G3 47k
MQ105 Net-_Q104-S_ XB3 GND 2N7000
MQ104 G3 A3 Net-_Q104-S_ 2N7000
MQ78 S2_n C2 GND 2N7000
R58 +5V S3 47k
MQ89 Net-_Q88-S_ T2 GND 2N7000
MQ88 C3 G2 Net-_Q88-S_ 2N7000
R49 +5V T2 47k
MQ87 Net-_Q86-S_ C2 GND 2N7000
MQ86 T2 P2 Net-_Q86-S_ 2N7000
MQ85 Net-_Q84-S_ XB2 GND 2N7000
MQ84 G2 A2 Net-_Q84-S_ 2N7000
R48 +5V G2 47k
R46 +5V S2_d 47k
MQ82 S2 S2_n GND 2N7000
R47 +5V S2 47k
R61 +5V C4 47k
R60 +5V T3 47k
MQ83 S2 S2_d GND 2N7000
MQ81 S2_d S2_a GND 2N7000
R32 +5V P1 47k
R33 +5V S1_n 47k
MQ58 S1_n C1 GND 2N7000
MQ57 S1_n P1 GND 2N7000
MQ55 P1 P1_n GND 2N7000
MQ56 P1 P1_d GND 2N7000
MQ62 S1 S1_n GND 2N7000
MQ63 S1 S1_d GND 2N7000
MQ59 S1_a P1 Net-_Q59-S_ 2N7000
MQ60 Net-_Q59-S_ C1 GND 2N7000
MQ61 S1_d S1_a GND 2N7000
R35 +5V S1_d 47k
R34 +5V S1_a 47k
MQ37 S0_n P0 GND 2N7000
MQ38 S0_n SUB GND 2N7000
R27 +5V T0 47k
R28 +5V C1 47k
R29 +5V P1_n 47k
R30 +5V P1_a 47k
R31 +5V P1_d 47k
R8 +5V XBB1 47k
MQ13 Net-_Q12-S_ SUB GND 2N7000
MQ12 XBB1 BN1 Net-_Q12-S_ 2N7000
R9 +5V XB1 47k
MQ15 Net-_Q14-S_ XBB1 GND 2N7000
MQ14 XB1 XBA1 Net-_Q14-S_ 2N7000
R10 +5V BN2 47k
MQ16 BN2 B2 GND 2N7000
MQ18 Net-_Q17-S_ SUBN GND 2N7000
MQ17 XBA2 B2 Net-_Q17-S_ 2N7000
R11 +5V XBA2 47k
R12 +5V XBB2 47k
MQ20 Net-_Q19-S_ SUB GND 2N7000
MQ19 XBB2 BN2 Net-_Q19-S_ 2N7000
R13 +5V XB2 47k
MQ22 Net-_Q21-S_ XBB2 GND 2N7000
MQ21 XB2 XBA2 Net-_Q21-S_ 2N7000
R14 +5V BN3 47k
MQ23 BN3 B3 GND 2N7000
V9003 A2 GND PWL( 0 0 0.0003995 0 0.0004005 5 0.0007995 5 0.0008005 5 0.0011995 5 0.0012005 0 0.0015995 0 0.0016005 0 0.0019995 0 0.0020005 5 0.0023995 5 0.0024005 0 0.0027995 0 0.0028005 0 0.0031995 0 0.0032005 5 0.0035995 5 0.0036005 5 0.0039995 5 0.0040005 0 0.0043995 0 0.0044005 5 0.0047995 5 0.0048005 5 0.0052 5 )
V9002 A1 GND PWL( 0 5 0.0003995 5 0.0004005 5 0.0007995 5 0.0008005 5 0.0011995 5 0.0012005 5 0.0015995 5 0.0016005 0 0.0019995 0 0.0020005 5 0.0023995 5 0.0024005 0 0.0027995 0 0.0028005 0 0.0031995 0 0.0032005 0 0.0035995 0 0.0036005 0 0.0039995 0 0.0040005 0 0.0043995 0 0.0044005 5 0.0047995 5 0.0048005 0 0.0052 0 )
V9001 A0 GND PWL( 0 5 0.0003995 5 0.0004005 5 0.0007995 5 0.0008005 0 0.0011995 0 0.0012005 0 0.0015995 0 0.0016005 5 0.0019995 5 0.0020005 5 0.0023995 5 0.0024005 0 0.0027995 0 0.0028005 0 0.0031995 0 0.0032005 5 0.0035995 5 0.0036005 0 0.0039995 0 0.0040005 5 0.0043995 5 0.0044005 5 0.0047995 5 0.0048005 5 0.0052 5 )
V9006 B1 GND PWL( 0 0 0.0003995 0 0.0004005 0 0.0007995 0 0.0008005 5 0.0011995 5 0.0012005 0 0.0015995 0 0.0016005 5 0.0019995 5 0.0020005 0 0.0023995 0 0.0024005 0 0.0027995 0 0.0028005 0 0.0031995 0 0.0032005 5 0.0035995 5 0.0036005 0 0.0039995 0 0.0040005 5 0.0043995 5 0.0044005 0 0.0047995 0 0.0048005 5 0.0052 5 )
V9004 A3 GND PWL( 0 0 0.0003995 0 0.0004005 0 0.0007995 0 0.0008005 0 0.0011995 0 0.0012005 0 0.0015995 0 0.0016005 5 0.0019995 5 0.0020005 5 0.0023995 5 0.0024005 0 0.0027995 0 0.0028005 5 0.0031995 5 0.0032005 0 0.0035995 0 0.0036005 5 0.0039995 5 0.0040005 0 0.0043995 0 0.0044005 0 0.0047995 0 0.0048005 0 0.0052 0 )
V9005 B0 GND PWL( 0 0 0.0003995 0 0.0004005 5 0.0007995 5 0.0008005 0 0.0011995 0 0.0012005 5 0.0015995 5 0.0016005 5 0.0019995 5 0.0020005 5 0.0023995 5 0.0024005 0 0.0027995 0 0.0028005 0 0.0031995 0 0.0032005 5 0.0035995 5 0.0036005 0 0.0039995 0 0.0040005 5 0.0043995 5 0.0044005 5 0.0047995 5 0.0048005 5 0.0052 5 )
R9003 +5V BUS2# 10k
V9009 SUB GND PWL( 0 0 0.0003995 0 0.0004005 5 0.0007995 5 0.0008005 5 0.0011995 5 0.0012005 5 0.0015995 5 0.0016005 0 0.0019995 0 0.0020005 0 0.0023995 0 0.0024005 5 0.0027995 5 0.0028005 0 0.0031995 0 0.0032005 5 0.0035995 5 0.0036005 5 0.0039995 5 0.0040005 0 0.0043995 0 0.0044005 5 0.0047995 5 0.0048005 0 0.0052 0 )
V9007 B2 GND PWL( 0 5 0.0003995 5 0.0004005 5 0.0007995 5 0.0008005 5 0.0011995 5 0.0012005 5 0.0015995 5 0.0016005 5 0.0019995 5 0.0020005 0 0.0023995 0 0.0024005 0 0.0027995 0 0.0028005 0 0.0031995 0 0.0032005 0 0.0035995 0 0.0036005 5 0.0039995 5 0.0040005 5 0.0043995 5 0.0044005 0 0.0047995 0 0.0048005 0 0.0052 0 )
V9008 B3 GND PWL( 0 0 0.0003995 0 0.0004005 0 0.0007995 0 0.0008005 0 0.0011995 0 0.0012005 0 0.0015995 0 0.0016005 0 0.0019995 0 0.0020005 0 0.0023995 0 0.0024005 0 0.0027995 0 0.0028005 5 0.0031995 5 0.0032005 0 0.0035995 0 0.0036005 0 0.0039995 0 0.0040005 5 0.0043995 5 0.0044005 0 0.0047995 0 0.0048005 0 0.0052 0 )
V9010 EO GND PWL( 0 5 0.0003995 5 0.0004005 5 0.0007995 5 0.0008005 5 0.0011995 5 0.0012005 5 0.0015995 5 0.0016005 5 0.0019995 5 0.0020005 5 0.0023995 5 0.0024005 5 0.0027995 5 0.0028005 5 0.0031995 5 0.0032005 5 0.0035995 5 0.0036005 5 0.0039995 5 0.0040005 5 0.0043995 5 0.0044005 5 0.0047995 5 0.0048005 0 0.0052 0 )
V9011 +5V GND DC 5
R9004 +5V BUS3# 10k
R9001 +5V BUS0# 10k
R9002 +5V BUS1# 10k
.end
