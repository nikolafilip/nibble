.title KiCad schematic
.include "/Users/nikolafilip/projects/nibble/lib/2N7000.lib"
.include "/Users/nikolafilip/projects/nibble/lib/led.lib"
.tran 2u 0.0084
R109 +5V OR3 47k
MQ190 Net-_Q189-S_ G3 GND 2N7000
MQ189 OR3 PN3 Net-_Q189-S_ 2N7000
R110 +5V RS3 47k
MQ192 Net-_Q191-S_ S3 GND 2N7000
MQ191 RS3 FS Net-_Q191-S_ 2N7000
R111 +5V RA3 47k
MQ194 Net-_Q193-S_ AND3 GND 2N7000
MQ193 RA3 FA Net-_Q193-S_ 2N7000
R133 +5V Net-_D6-A_ 1k
MQ233 Net-_D6-K_ ZF GND 2N7000
D6 Net-_D6-A_ Net-_D6-K_ LEDRED
R123 +5V BD1 47k
MQ218 BD1 BDN1 GND 2N7000
MQ219 BUS1# BD1 GND 2N7000
MQ232 Net-_D5-K_ CF GND 2N7000
R132 +5V Net-_D5-A_ 1k
D5 Net-_D5-A_ Net-_D5-K_ LEDRED
R124 +5V BDN2 47k
MQ220 BDN2 R2 Net-_Q220-S_ 2N7000
MQ221 Net-_Q220-S_ EO GND 2N7000
R125 +5V BD2 47k
MQ222 BD2 BDN2 GND 2N7000
MQ223 BUS2# BD2 GND 2N7000
R126 +5V BDN3 47k
MQ201 Net-_Q200-S_ RO3 GND 2N7000
MQ225 Net-_Q224-S_ EO GND 2N7000
MQ224 BDN3 R3 Net-_Q224-S_ 2N7000
R127 +5V BD3 47k
MQ226 BD3 BDN3 GND 2N7000
MQ227 BUS3# BD3 GND 2N7000
R74 +5V FO 47k
MQ128 FO F1N GND 2N7000
MQ129 FO F0 GND 2N7000
R75 +5V FXN 47k
MQ131 Net-_Q130-S_ F0 GND 2N7000
MQ130 FXN F1 Net-_Q130-S_ 2N7000
R76 +5V FX 47k
MQ132 FX FXN GND 2N7000
R83 +5V RX0 47k
MQ143 RX0 FX Net-_Q143-S_ 2N7000
MQ144 Net-_Q143-S_ P0 GND 2N7000
R82 +5V RO0 47k
MQ142 Net-_Q141-S_ OR0 GND 2N7000
MQ141 RO0 FO Net-_Q141-S_ 2N7000
MQ139 RA0 FA Net-_Q139-S_ 2N7000
MQ140 Net-_Q139-S_ AND0 GND 2N7000
R81 +5V RA0 47k
R95 +5V RMN1 47k
MQ166 RMN1 RM1 GND 2N7000
MQ169 AND2 G2 GND 2N7000
R97 +5V AND2 47k
R96 +5V R1 47k
MQ168 Net-_Q167-S_ RX1 GND 2N7000
MQ167 R1 RMN1 Net-_Q167-S_ 2N7000
R87 +5V AND1 47k
MQ151 AND1 G1 GND 2N7000
MQ152 PN1 P1 GND 2N7000
R88 +5V PN1 47k
R102 +5V RO2 47k
MQ177 RO2 FO Net-_Q177-S_ 2N7000
MQ178 Net-_Q177-S_ OR2 GND 2N7000
R100 +5V RS2 47k
MQ173 RS2 FS Net-_Q173-S_ 2N7000
MQ174 Net-_Q173-S_ S2 GND 2N7000
R101 +5V RA2 47k
MQ176 Net-_Q175-S_ AND2 GND 2N7000
MQ175 RA2 FA Net-_Q175-S_ 2N7000
R89 +5V OR1 47k
MQ153 OR1 PN1 Net-_Q153-S_ 2N7000
MQ154 Net-_Q153-S_ G1 GND 2N7000
R90 +5V RS1 47k
MQ156 Net-_Q155-S_ S1 GND 2N7000
MQ155 RS1 FS Net-_Q155-S_ 2N7000
R103 +5V RX2 47k
MQ180 Net-_Q179-S_ P2 GND 2N7000
MQ179 RX2 FX Net-_Q179-S_ 2N7000
R104 +5V RM2 47k
MQ181 RM2 RS2 Net-_Q181-S_ 2N7000
MQ183 Net-_Q182-S_ RO2 GND 2N7000
MQ182 Net-_Q181-S_ RA2 Net-_Q182-S_ 2N7000
MQ203 R3 RMN3 Net-_Q203-S_ 2N7000
MQ204 Net-_Q203-S_ RX3 GND 2N7000
R114 +5V RM3 47k
MQ199 RM3 RS3 Net-_Q199-S_ 2N7000
MQ200 Net-_Q199-S_ RA3 Net-_Q200-S_ 2N7000
R116 +5V R3 47k
R115 +5V RMN3 47k
MQ202 RMN3 RM3 GND 2N7000
R99 +5V OR2 47k
MQ172 Net-_Q171-S_ G2 GND 2N7000
MQ171 OR2 PN2 Net-_Q171-S_ 2N7000
R112 +5V RO3 47k
MQ196 Net-_Q195-S_ OR3 GND 2N7000
MQ195 RO3 FO Net-_Q195-S_ 2N7000
R113 +5V RX3 47k
MQ198 Net-_Q197-S_ P3 GND 2N7000
MQ197 RX3 FX Net-_Q197-S_ 2N7000
R98 +5V PN2 47k
MQ170 PN2 P2 GND 2N7000
MQ145 RM0 RS0 Net-_Q145-S_ 2N7000
R84 +5V RM0 47k
R85 +5V RMN0 47k
MQ148 RMN0 RM0 GND 2N7000
MQ150 Net-_Q149-S_ RX0 GND 2N7000
MQ149 R0 RMN0 Net-_Q149-S_ 2N7000
R86 +5V R0 47k
MQ146 Net-_Q145-S_ RA0 Net-_Q146-S_ 2N7000
MQ147 Net-_Q146-S_ RO0 GND 2N7000
R108 +5V PN3 47k
R107 +5V AND3 47k
MQ187 AND3 G3 GND 2N7000
MQ188 PN3 P3 GND 2N7000
MQ165 Net-_Q164-S_ RO1 GND 2N7000
R105 +5V RMN2 47k
MQ185 R2 RMN2 Net-_Q185-S_ 2N7000
MQ186 Net-_Q185-S_ RX2 GND 2N7000
R106 +5V R2 47k
MQ184 RMN2 RM2 GND 2N7000
MQ206 Net-_Q205-S_ FS GND 2N7000
MQ205 CFN C4 Net-_Q205-S_ 2N7000
R117 +5V CFN 47k
MQ207 CF CFN GND 2N7000
MQ228 Net-_D1-K_ R3 GND 2N7000
MQ229 Net-_D2-K_ R2 GND 2N7000
R129 +5V Net-_D2-A_ 1k
D2 Net-_D2-A_ Net-_D2-K_ LEDRED
D1 Net-_D1-A_ Net-_D1-K_ LEDRED
R128 +5V Net-_D1-A_ 1k
MQ231 Net-_D4-K_ R0 GND 2N7000
R131 +5V Net-_D4-A_ 1k
D4 Net-_D4-A_ Net-_D4-K_ LEDRED
R130 +5V Net-_D3-A_ 1k
MQ230 Net-_D3-K_ R1 GND 2N7000
D3 Net-_D3-A_ Net-_D3-K_ LEDRED
MQ217 Net-_Q216-S_ EO GND 2N7000
MQ211 ZF R3 GND 2N7000
MQ215 BUS0# BD0 GND 2N7000
R122 +5V BDN1 47k
MQ216 BDN1 R1 Net-_Q216-S_ 2N7000
R120 +5V BDN0 47k
MQ212 BDN0 R0 Net-_Q212-S_ 2N7000
MQ213 Net-_Q212-S_ EO GND 2N7000
R121 +5V BD0 47k
MQ214 BD0 BDN0 GND 2N7000
MQ210 ZF R2 GND 2N7000
R119 +5V ZF 47k
R118 +5V CF 47k
MQ208 ZF R0 GND 2N7000
MQ209 ZF R1 GND 2N7000
R91 +5V RA1 47k
MQ158 Net-_Q157-S_ AND1 GND 2N7000
MQ157 RA1 FA Net-_Q157-S_ 2N7000
R92 +5V RO1 47k
MQ160 Net-_Q159-S_ OR1 GND 2N7000
MQ159 RO1 FO Net-_Q159-S_ 2N7000
MQ162 Net-_Q161-S_ P1 GND 2N7000
R93 +5V RX1 47k
MQ161 RX1 FX Net-_Q161-S_ 2N7000
MQ133 AND0 G0 GND 2N7000
R77 +5V AND0 47k
MQ134 PN0 P0 GND 2N7000
R78 +5V PN0 47k
MQ118 T3 P3 Net-_Q118-S_ 2N7000
MQ119 Net-_Q118-S_ C3 GND 2N7000
MQ120 C4 G3 Net-_Q120-S_ 2N7000
MQ121 Net-_Q120-S_ T3 GND 2N7000
R70 +5V F0N 47k
MQ123 F1N F1 GND 2N7000
MQ122 F0N F0 GND 2N7000
MQ127 FA F0N GND 2N7000
R73 +5V FA 47k
MQ126 FA F1 GND 2N7000
R72 +5V FS 47k
MQ125 FS F0 GND 2N7000
MQ124 FS F1 GND 2N7000
R71 +5V F1N 47k
MQ163 RM1 RS1 Net-_Q163-S_ 2N7000
R94 +5V RM1 47k
MQ164 Net-_Q163-S_ RA1 Net-_Q164-S_ 2N7000
R80 +5V RS0 47k
MQ137 RS0 FS Net-_Q137-S_ 2N7000
MQ138 Net-_Q137-S_ S0 GND 2N7000
MQ136 Net-_Q135-S_ G0 GND 2N7000
MQ135 OR0 PN0 Net-_Q135-S_ 2N7000
R79 +5V OR0 47k
C2 +5V GND 10u
C1 +5V GND 100n
MQ2 BN0 B0 GND 2N7000
R2 +5V BN0 47k
R17 +5V XBA2 47k
R16 +5V BB2N 47k
R3 +5V BB0N 47k
R4 +5V BB0 47k
MQ3 BB0N B0 GND 2N7000
MQ4 BB0N ONE GND 2N7000
MQ5 BB0 BB0N GND 2N7000
R18 +5V XBB2 47k
MQ7 Net-_Q6-S_ SUBN GND 2N7000
R19 +5V XB2 47k
R6 +5V XBB0 47k
MQ6 XBA0 BB0 Net-_Q6-S_ 2N7000
R5 +5V XBA0 47k
MQ9 Net-_Q8-S_ SUB GND 2N7000
MQ8 XBB0 BB0N Net-_Q8-S_ 2N7000
R20 +5V BN3 47k
R36 +5V C1 47k
MQ58 T0 P0 Net-_Q58-S_ 2N7000
MQ59 Net-_Q58-S_ SUB GND 2N7000
R35 +5V T0 47k
R49 +5V P2_a 47k
MQ84 P2_a A2 Net-_Q84-S_ 2N7000
MQ61 Net-_Q60-S_ T0 GND 2N7000
MQ60 C1 G0 Net-_Q60-S_ 2N7000
MQ86 P2_d P2_a GND 2N7000
R50 +5V P2_d 47k
R64 +5V S3_a 47k
MQ112 Net-_Q111-S_ C3 GND 2N7000
MQ111 S3_a P3 Net-_Q111-S_ 2N7000
MQ110 S3_n C3 GND 2N7000
MQ109 S3_n P3 GND 2N7000
MQ85 Net-_Q84-S_ XB2 GND 2N7000
R63 +5V S3_n 47k
MQ88 P2 P2_d GND 2N7000
MQ87 P2 P2_n GND 2N7000
MQ63 P1_n XB1 GND 2N7000
MQ62 P1_n A1 GND 2N7000
R38 +5V P1_a 47k
MQ64 P1_a A1 Net-_Q64-S_ 2N7000
MQ65 Net-_Q64-S_ XB1 GND 2N7000
R51 +5V P2 47k
R52 +5V S2_n 47k
MQ89 S2_n P2 GND 2N7000
MQ90 S2_n C2 GND 2N7000
R37 +5V P1_n 47k
R65 +5V S3_d 47k
MQ113 S3_d S3_a GND 2N7000
R66 +5V S3 47k
MQ115 S3 S3_d GND 2N7000
MQ114 S3 S3_n GND 2N7000
MQ53 S0_d S0_a GND 2N7000
R32 +5V S0_d 47k
R46 +5V T1 47k
R44 +5V S1 47k
R45 +5V G1 47k
MQ75 S1 S1_d GND 2N7000
MQ74 S1 S1_n GND 2N7000
MQ77 Net-_Q76-S_ XB1 GND 2N7000
MQ76 G1 A1 Net-_Q76-S_ 2N7000
R43 +5V S1_d 47k
MQ73 S1_d S1_a GND 2N7000
R57 +5V T2 47k
MQ101 Net-_Q100-S_ T2 GND 2N7000
MQ100 C3 G2 Net-_Q100-S_ 2N7000
R58 +5V C3 47k
MQ99 Net-_Q98-S_ C2 GND 2N7000
MQ98 T2 P2 Net-_Q98-S_ 2N7000
MQ103 P3_n XB3 GND 2N7000
MQ102 P3_n A3 GND 2N7000
MQ105 Net-_Q104-S_ XB3 GND 2N7000
MQ104 P3_a A3 Net-_Q104-S_ 2N7000
R59 +5V P3_n 47k
R60 +5V P3_a 47k
MQ78 T1 P1 Net-_Q78-S_ 2N7000
MQ79 Net-_Q78-S_ C1 GND 2N7000
MQ49 S0_n P0 GND 2N7000
MQ50 S0_n SUB GND 2N7000
MQ51 S0_a P0 Net-_Q51-S_ 2N7000
MQ52 Net-_Q51-S_ SUB GND 2N7000
R31 +5V S0_a 47k
MQ48 P0 P0_d GND 2N7000
MQ47 P0 P0_n GND 2N7000
R29 +5V P0 47k
R30 +5V S0_n 47k
R55 +5V S2 47k
R56 +5V G2 47k
MQ95 S2 S2_d GND 2N7000
MQ94 S2 S2_n GND 2N7000
MQ97 Net-_Q96-S_ XB2 GND 2N7000
MQ96 G2 A2 Net-_Q96-S_ 2N7000
MQ71 S1_a P1 Net-_Q71-S_ 2N7000
MQ72 Net-_Q71-S_ C1 GND 2N7000
MQ69 S1_n P1 GND 2N7000
MQ70 S1_n C1 GND 2N7000
R42 +5V S1_a 47k
R41 +5V S1_n 47k
R26 +5V P0_n 47k
MQ43 P0_n XB0 GND 2N7000
MQ42 P0_n A0 GND 2N7000
R27 +5V P0_a 47k
MQ44 P0_a A0 Net-_Q44-S_ 2N7000
MQ45 Net-_Q44-S_ XB0 GND 2N7000
R28 +5V P0_d 47k
MQ46 P0_d P0_a GND 2N7000
R69 +5V C4 47k
R40 +5V P1 47k
MQ68 P1 P1_d GND 2N7000
MQ67 P1 P1_n GND 2N7000
R54 +5V S2_d 47k
MQ93 S2_d S2_a GND 2N7000
R68 +5V T3 47k
MQ35 BB3N BB3 GND 2N7000
R22 +5V BB3N 47k
MQ37 Net-_Q36-S_ SUBN GND 2N7000
R23 +5V XBA3 47k
MQ36 XBA3 BB3 Net-_Q36-S_ 2N7000
MQ57 Net-_Q56-S_ XB0 GND 2N7000
MQ56 G0 A0 Net-_Q56-S_ 2N7000
MQ82 P2_n A2 GND 2N7000
R48 +5V P2_n 47k
R34 +5V G0 47k
R33 +5V S0 47k
MQ55 S0 S0_d GND 2N7000
MQ54 S0 S0_n GND 2N7000
MQ83 P2_n XB2 GND 2N7000
MQ80 C2 G1 Net-_Q80-S_ 2N7000
MQ81 Net-_Q80-S_ T1 GND 2N7000
R47 +5V C2 47k
R62 +5V P3 47k
R61 +5V P3_d 47k
MQ107 P3 P3_n GND 2N7000
MQ106 P3_d P3_a GND 2N7000
MQ108 P3 P3_d GND 2N7000
R24 +5V XBB3 47k
MQ39 Net-_Q38-S_ SUB GND 2N7000
MQ38 XBB3 BB3N Net-_Q38-S_ 2N7000
R25 +5V XB3 47k
MQ40 XB3 XBA3 Net-_Q40-S_ 2N7000
MQ41 Net-_Q40-S_ XBB3 GND 2N7000
MQ29 Net-_Q28-S_ SUB GND 2N7000
MQ28 XBB2 BB2N Net-_Q28-S_ 2N7000
MQ27 Net-_Q26-S_ SUBN GND 2N7000
MQ26 XBA2 BB2 Net-_Q26-S_ 2N7000
MQ11 Net-_Q10-S_ XBB0 GND 2N7000
MQ10 XB0 XBA0 Net-_Q10-S_ 2N7000
MQ12 BN1 B1 GND 2N7000
MQ32 BN3 B3 GND 2N7000
MQ30 XB2 XBA2 Net-_Q30-S_ 2N7000
MQ33 BB3 BN3 GND 2N7000
MQ23 BB2 BN2 GND 2N7000
MQ25 BB2N BB2 GND 2N7000
MQ34 BB3 ONE GND 2N7000
R21 +5V BB3 47k
MQ31 Net-_Q30-S_ XBB2 GND 2N7000
R7 +5V XB0 47k
R15 +5V BB2 47k
MQ1 SUBN SUB GND 2N7000
MQ24 BB2 ONE GND 2N7000
MQ14 BB1 ONE GND 2N7000
MQ13 BB1 BN1 GND 2N7000
R8 +5V BN1 47k
R1 +5V SUBN 47k
R9 +5V BB1 47k
MQ15 BB1N BB1 GND 2N7000
R10 +5V BB1N 47k
MQ17 Net-_Q16-S_ SUBN GND 2N7000
MQ16 XBA1 BB1 Net-_Q16-S_ 2N7000
R11 +5V XBA1 47k
R12 +5V XBB1 47k
MQ19 Net-_Q18-S_ SUB GND 2N7000
MQ18 XBB1 BB1N Net-_Q18-S_ 2N7000
R13 +5V XB1 47k
MQ21 Net-_Q20-S_ XBB1 GND 2N7000
MQ20 XB1 XBA1 Net-_Q20-S_ 2N7000
R14 +5V BN2 47k
MQ22 BN2 B2 GND 2N7000
R39 +5V P1_d 47k
MQ66 P1_d P1_a GND 2N7000
R53 +5V S2_a 47k
MQ92 Net-_Q91-S_ C2 GND 2N7000
MQ91 S2_a P2 Net-_Q91-S_ 2N7000
R67 +5V G3 47k
MQ117 Net-_Q116-S_ XB3 GND 2N7000
MQ116 G3 A3 Net-_Q116-S_ 2N7000
V9014 +5V GND DC 5
V9003 A2 GND PWL( 0 0 0.0003995 0 0.0004005 5 0.0007995 5 0.0008005 5 0.0011995 5 0.0012005 0 0.0015995 0 0.0016005 0 0.0019995 0 0.0020005 5 0.0023995 5 0.0024005 0 0.0027995 0 0.0028005 0 0.0031995 0 0.0032005 5 0.0035995 5 0.0036005 5 0.0039995 5 0.0040005 0 0.0043995 0 0.0044005 5 0.0047995 5 0.0048005 5 0.0051995 5 0.0052005 5 0.0055995 5 0.0056005 0 0.0059995 0 0.0060005 0 0.0063995 0 0.0064005 5 0.0067995 5 0.0068005 5 0.0071995 5 0.0072005 5 0.0075995 5 0.0076005 5 0.0079995 5 0.0080005 5 0.0084 5 )
V9002 A1 GND PWL( 0 5 0.0003995 5 0.0004005 5 0.0007995 5 0.0008005 5 0.0011995 5 0.0012005 5 0.0015995 5 0.0016005 0 0.0019995 0 0.0020005 5 0.0023995 5 0.0024005 0 0.0027995 0 0.0028005 0 0.0031995 0 0.0032005 0 0.0035995 0 0.0036005 0 0.0039995 0 0.0040005 0 0.0043995 0 0.0044005 5 0.0047995 5 0.0048005 0 0.0051995 0 0.0052005 5 0.0055995 5 0.0056005 0 0.0059995 0 0.0060005 0 0.0063995 0 0.0064005 0 0.0067995 0 0.0068005 0 0.0071995 0 0.0072005 0 0.0075995 0 0.0076005 5 0.0079995 5 0.0080005 0 0.0084 0 )
V9001 A0 GND PWL( 0 5 0.0003995 5 0.0004005 5 0.0007995 5 0.0008005 0 0.0011995 0 0.0012005 0 0.0015995 0 0.0016005 5 0.0019995 5 0.0020005 5 0.0023995 5 0.0024005 0 0.0027995 0 0.0028005 0 0.0031995 0 0.0032005 5 0.0035995 5 0.0036005 0 0.0039995 0 0.0040005 5 0.0043995 5 0.0044005 5 0.0047995 5 0.0048005 5 0.0051995 5 0.0052005 5 0.0055995 5 0.0056005 0 0.0059995 0 0.0060005 5 0.0063995 5 0.0064005 0 0.0067995 0 0.0068005 0 0.0071995 0 0.0072005 0 0.0075995 0 0.0076005 5 0.0079995 5 0.0080005 5 0.0084 5 )
V9004 A3 GND PWL( 0 0 0.0003995 0 0.0004005 0 0.0007995 0 0.0008005 0 0.0011995 0 0.0012005 0 0.0015995 0 0.0016005 5 0.0019995 5 0.0020005 5 0.0023995 5 0.0024005 0 0.0027995 0 0.0028005 5 0.0031995 5 0.0032005 0 0.0035995 0 0.0036005 5 0.0039995 5 0.0040005 0 0.0043995 0 0.0044005 0 0.0047995 0 0.0048005 0 0.0051995 0 0.0052005 5 0.0055995 5 0.0056005 0 0.0059995 0 0.0060005 5 0.0063995 5 0.0064005 5 0.0067995 5 0.0068005 5 0.0071995 5 0.0072005 5 0.0075995 5 0.0076005 5 0.0079995 5 0.0080005 0 0.0084 0 )
V9005 B0 GND PWL( 0 0 0.0003995 0 0.0004005 5 0.0007995 5 0.0008005 0 0.0011995 0 0.0012005 5 0.0015995 5 0.0016005 5 0.0019995 5 0.0020005 5 0.0023995 5 0.0024005 0 0.0027995 0 0.0028005 0 0.0031995 0 0.0032005 5 0.0035995 5 0.0036005 0 0.0039995 0 0.0040005 5 0.0043995 5 0.0044005 5 0.0047995 5 0.0048005 0 0.0051995 0 0.0052005 5 0.0055995 5 0.0056005 5 0.0059995 5 0.0060005 0 0.0063995 0 0.0064005 0 0.0067995 0 0.0068005 0 0.0071995 0 0.0072005 0 0.0075995 0 0.0076005 5 0.0079995 5 0.0080005 5 0.0084 5 )
V9006 B1 GND PWL( 0 0 0.0003995 0 0.0004005 0 0.0007995 0 0.0008005 5 0.0011995 5 0.0012005 0 0.0015995 0 0.0016005 5 0.0019995 5 0.0020005 0 0.0023995 0 0.0024005 0 0.0027995 0 0.0028005 0 0.0031995 0 0.0032005 5 0.0035995 5 0.0036005 0 0.0039995 0 0.0040005 5 0.0043995 5 0.0044005 0 0.0047995 0 0.0048005 0 0.0051995 0 0.0052005 0 0.0055995 0 0.0056005 5 0.0059995 5 0.0060005 5 0.0063995 5 0.0064005 5 0.0067995 5 0.0068005 5 0.0071995 5 0.0072005 5 0.0075995 5 0.0076005 5 0.0079995 5 0.0080005 5 0.0084 5 )
V9007 B2 GND PWL( 0 5 0.0003995 5 0.0004005 5 0.0007995 5 0.0008005 5 0.0011995 5 0.0012005 5 0.0015995 5 0.0016005 5 0.0019995 5 0.0020005 0 0.0023995 0 0.0024005 0 0.0027995 0 0.0028005 0 0.0031995 0 0.0032005 0 0.0035995 0 0.0036005 5 0.0039995 5 0.0040005 5 0.0043995 5 0.0044005 0 0.0047995 0 0.0048005 0 0.0051995 0 0.0052005 0 0.0055995 0 0.0056005 0 0.0059995 0 0.0060005 0 0.0063995 0 0.0064005 0 0.0067995 0 0.0068005 0 0.0071995 0 0.0072005 0 0.0075995 0 0.0076005 5 0.0079995 5 0.0080005 0 0.0084 0 )
V9012 F1 GND PWL( 0 0 0.0003995 0 0.0004005 0 0.0007995 0 0.0008005 0 0.0011995 0 0.0012005 0 0.0015995 0 0.0016005 0 0.0019995 0 0.0020005 0 0.0023995 0 0.0024005 0 0.0027995 0 0.0028005 0 0.0031995 0 0.0032005 0 0.0035995 0 0.0036005 0 0.0039995 0 0.0040005 0 0.0043995 0 0.0044005 0 0.0047995 0 0.0048005 0 0.0051995 0 0.0052005 0 0.0055995 0 0.0056005 0 0.0059995 0 0.0060005 0 0.0063995 0 0.0064005 0 0.0067995 0 0.0068005 5 0.0071995 5 0.0072005 5 0.0075995 5 0.0076005 5 0.0079995 5 0.0080005 0 0.0084 0 )
R9001 +5V BUS0# 10k
V9011 F0 GND PWL( 0 0 0.0003995 0 0.0004005 0 0.0007995 0 0.0008005 0 0.0011995 0 0.0012005 0 0.0015995 0 0.0016005 0 0.0019995 0 0.0020005 0 0.0023995 0 0.0024005 0 0.0027995 0 0.0028005 0 0.0031995 0 0.0032005 0 0.0035995 0 0.0036005 0 0.0039995 0 0.0040005 0 0.0043995 0 0.0044005 0 0.0047995 0 0.0048005 0 0.0051995 0 0.0052005 0 0.0055995 0 0.0056005 0 0.0059995 0 0.0060005 0 0.0063995 0 0.0064005 5 0.0067995 5 0.0068005 0 0.0071995 0 0.0072005 5 0.0075995 5 0.0076005 5 0.0079995 5 0.0080005 0 0.0084 0 )
V9013 EO GND PWL( 0 5 0.0003995 5 0.0004005 5 0.0007995 5 0.0008005 5 0.0011995 5 0.0012005 5 0.0015995 5 0.0016005 5 0.0019995 5 0.0020005 5 0.0023995 5 0.0024005 5 0.0027995 5 0.0028005 5 0.0031995 5 0.0032005 5 0.0035995 5 0.0036005 5 0.0039995 5 0.0040005 5 0.0043995 5 0.0044005 5 0.0047995 5 0.0048005 5 0.0051995 5 0.0052005 5 0.0055995 5 0.0056005 5 0.0059995 5 0.0060005 5 0.0063995 5 0.0064005 5 0.0067995 5 0.0068005 5 0.0071995 5 0.0072005 5 0.0075995 5 0.0076005 5 0.0079995 5 0.0080005 0 0.0084 0 )
R9002 +5V BUS1# 10k
V9009 SUB GND PWL( 0 0 0.0003995 0 0.0004005 5 0.0007995 5 0.0008005 5 0.0011995 5 0.0012005 5 0.0015995 5 0.0016005 0 0.0019995 0 0.0020005 0 0.0023995 0 0.0024005 5 0.0027995 5 0.0028005 0 0.0031995 0 0.0032005 5 0.0035995 5 0.0036005 5 0.0039995 5 0.0040005 0 0.0043995 0 0.0044005 5 0.0047995 5 0.0048005 0 0.0051995 0 0.0052005 0 0.0055995 0 0.0056005 5 0.0059995 5 0.0060005 5 0.0063995 5 0.0064005 0 0.0067995 0 0.0068005 0 0.0071995 0 0.0072005 0 0.0075995 0 0.0076005 0 0.0079995 0 0.0080005 0 0.0084 0 )
V9008 B3 GND PWL( 0 0 0.0003995 0 0.0004005 0 0.0007995 0 0.0008005 0 0.0011995 0 0.0012005 0 0.0015995 0 0.0016005 0 0.0019995 0 0.0020005 0 0.0023995 0 0.0024005 0 0.0027995 0 0.0028005 5 0.0031995 5 0.0032005 0 0.0035995 0 0.0036005 0 0.0039995 0 0.0040005 5 0.0043995 5 0.0044005 0 0.0047995 0 0.0048005 0 0.0051995 0 0.0052005 5 0.0055995 5 0.0056005 0 0.0059995 0 0.0060005 0 0.0063995 0 0.0064005 5 0.0067995 5 0.0068005 5 0.0071995 5 0.0072005 5 0.0075995 5 0.0076005 5 0.0079995 5 0.0080005 0 0.0084 0 )
V9010 ONE GND PWL( 0 0 0.0003995 0 0.0004005 0 0.0007995 0 0.0008005 0 0.0011995 0 0.0012005 0 0.0015995 0 0.0016005 0 0.0019995 0 0.0020005 0 0.0023995 0 0.0024005 0 0.0027995 0 0.0028005 0 0.0031995 0 0.0032005 0 0.0035995 0 0.0036005 0 0.0039995 0 0.0040005 0 0.0043995 0 0.0044005 0 0.0047995 0 0.0048005 5 0.0051995 5 0.0052005 5 0.0055995 5 0.0056005 5 0.0059995 5 0.0060005 5 0.0063995 5 0.0064005 0 0.0067995 0 0.0068005 0 0.0071995 0 0.0072005 0 0.0075995 0 0.0076005 0 0.0079995 0 0.0080005 0 0.0084 0 )
R9004 +5V BUS3# 10k
R9003 +5V BUS2# 10k
.end
