.title KiCad schematic
.include "/Users/nikolafilip/Desktop/2N3904.lib"
.ic v(L)=0 v(T1)=0 v(T2)=0 v(T3)=0 v(DN)=0 v(P0)=0 v(P1)=0 v(P2)=0 v(P3)=0 v(P4)=0 v(P5)=0 v(OUT_B4)=0 v(OUT_B5)=0 v(OUT_SIGN)=0 v(OUT_B3)=0 v(OUT_B2)=0 v(OUT_B1)=0 v(OUT_B0)=0
.tran 1u 0.0093
R788 +5V Net-_Q300-C_ 4.7k
Q300 Net-_Q300-C_ Net-_Q300-B_ Net-_Q300-E_ 2N3904
Q295 Net-_Q295-C_ Net-_Q295-B_ Net-_Q295-E_ 2N3904
R766 Net-_Q290-C_ Net-_Q295-B_ 10k
R775 +5V Net-_Q295-C_ 4.7k
Q301 Net-_Q300-E_ Net-_Q301-B_ GND 2N3904
R797 GND Net-_Q306-B_ 22k
Q306 Net-_Q306-C_ Net-_Q306-B_ Net-_Q306-E_ 2N3904
Q307 Net-_Q306-E_ Net-_Q307-B_ GND 2N3904
R795 GND Net-_Q307-B_ 22k
R793 Net-_Q302-C_ Net-_Q307-B_ 10k
R799 +5V Net-_Q306-C_ 4.7k
R792 OUT_B0 Net-_Q306-B_ 10k
R789 +5V Net-_Q302-C_ 4.7k
Q303 Net-_Q302-E_ Net-_Q303-B_ GND 2N3904
Q302 Net-_Q302-C_ Net-_Q302-B_ Net-_Q302-E_ 2N3904
R794 GND Net-_Q305-B_ 22k
Q305 Net-_Q304-E_ Net-_Q305-B_ GND 2N3904
R791 Net-_Q306-C_ Net-_Q305-B_ 10k
R796 GND Net-_Q304-B_ 22k
R790 Net-_Q300-C_ Net-_Q304-B_ 10k
Q304 OUT_B0 Net-_Q304-B_ Net-_Q304-E_ 2N3904
R798 +5V OUT_B0 2.2k
R740 OUT_B1 Net-_Q286-B_ 10k
Q286 Net-_Q286-C_ Net-_Q286-B_ Net-_Q286-E_ 2N3904
R745 GND Net-_Q286-B_ 22k
R741 Net-_Q282-C_ Net-_Q287-B_ 10k
Q287 Net-_Q286-E_ Net-_Q287-B_ GND 2N3904
R743 GND Net-_Q287-B_ 22k
R733 GND Net-_Q283-B_ 22k
Q283 Net-_Q282-E_ Net-_Q283-B_ GND 2N3904
R725 Net-_Q275-C_ Net-_Q279-B_ 10k
R730 Net-_Q274-C_ Net-_Q282-B_ 10k
R731 Net-_Q279-C_ Net-_Q283-B_ 10k
R727 +5V Net-_Q279-C_ 4.7k
Q279 Net-_Q279-C_ Net-_Q279-B_ GND 2N3904
R726 GND Net-_Q279-B_ 22k
R737 +5V Net-_Q282-C_ 4.7k
Q282 Net-_Q282-C_ Net-_Q282-B_ Net-_Q282-E_ 2N3904
R735 GND Net-_Q282-B_ 22k
R757 Net-_Q289-C_ Net-_Q293-B_ 10k
R756 Net-_Q288-C_ Net-_Q292-B_ 10k
R761 GND Net-_Q292-B_ 22k
R759 GND Net-_Q293-B_ 22k
Q292 Net-_Q292-C_ Net-_Q292-B_ Net-_Q292-E_ 2N3904
Q293 Net-_Q292-E_ Net-_Q293-B_ GND 2N3904
R753 +5V Net-_Q289-C_ 4.7k
R763 +5V Net-_Q292-C_ 4.7k
R755 Net-_Q288-C_ Net-_Q291-B_ 10k
R754 REG_D0 Net-_Q290-B_ 10k
R758 GND Net-_Q291-B_ 22k
R760 GND Net-_Q290-B_ 22k
Q291 Net-_Q290-E_ Net-_Q291-B_ GND 2N3904
Q290 Net-_Q290-C_ Net-_Q290-B_ Net-_Q290-E_ 2N3904
R739 Net-_Q286-C_ Net-_Q285-B_ 10k
R746 +5V OUT_B1 2.2k
Q284 OUT_B1 Net-_Q284-B_ Net-_Q284-E_ 2N3904
R738 Net-_Q280-C_ Net-_Q284-B_ 10k
R744 GND Net-_Q284-B_ 22k
R742 GND Net-_Q285-B_ 22k
Q285 Net-_Q284-E_ Net-_Q285-B_ GND 2N3904
R747 +5V Net-_Q286-C_ 4.7k
R751 +5V Net-_Q288-C_ 2.2k
R749 GND Net-_Q288-B_ 22k
Q288 Net-_Q288-C_ Net-_Q288-B_ GND 2N3904
R750 REG_D0 Net-_Q289-B_ 10k
Q289 Net-_Q289-C_ Net-_Q289-B_ GND 2N3904
R752 GND Net-_Q289-B_ 22k
R748 MEMCLK Net-_Q288-B_ 10k
Q280 Net-_Q280-C_ Net-_Q280-B_ Net-_Q280-E_ 2N3904
R736 +5V Net-_Q280-C_ 4.7k
R728 Net-_Q275-C_ Net-_Q280-B_ 10k
R729 Net-_Q274-C_ Net-_Q281-B_ 10k
Q281 Net-_Q280-E_ Net-_Q281-B_ GND 2N3904
R734 GND Net-_Q280-B_ 22k
R732 GND Net-_Q281-B_ 22k
Q108 ENCB_N0 Net-_Q108-B_ GND 2N3904
R277 GND Net-_Q108-B_ 22k
R255 X6 Net-_Q99-B_ 10k
R260 GND Net-_Q99-B_ 22k
R259 +5V ENCB_N2 4.7k
Q97 ENCB_N2 Net-_Q97-B_ GND 2N3904
R253 GND Net-_Q97-B_ 22k
R251 X7 Net-_Q97-B_ 10k
Q98 ENCB_N2 Net-_Q98-B_ GND 2N3904
R254 GND Net-_Q98-B_ 22k
R252 X5 Net-_Q98-B_ 10k
R275 +5V ENCB_N0 4.7k
Q106 ENCB_N0 Net-_Q106-B_ GND 2N3904
R272 GND Net-_Q106-B_ 22k
Q107 ENCB_N0 Net-_Q107-B_ GND 2N3904
R276 GND Net-_Q107-B_ 22k
R273 X5 Net-_Q107-B_ 10k
R271 GND Net-_Q105-B_ 22k
Q105 ENCB_N0 Net-_Q105-B_ GND 2N3904
R274 X1 Net-_Q108-B_ 10k
R264 X6 Net-_Q103-B_ 10k
R266 +5V ENCB_N1 4.7k
Q101 ENCB_N1 Net-_Q101-B_ GND 2N3904
R262 GND Net-_Q101-B_ 22k
R267 GND Net-_Q103-B_ 22k
Q103 ENCB_N1 Net-_Q103-B_ GND 2N3904
Q104 ENCB_N1 Net-_Q104-B_ GND 2N3904
R265 X2 Net-_Q104-B_ 10k
Q102 ENCB_N1 Net-_Q102-B_ GND 2N3904
R263 GND Net-_Q102-B_ 22k
Q99 ENCB_N2 Net-_Q99-B_ GND 2N3904
R256 X4 Net-_Q100-B_ 10k
R270 X3 Net-_Q106-B_ 10k
R269 X7 Net-_Q105-B_ 10k
R261 GND Net-_Q100-B_ 22k
Q100 ENCB_N2 Net-_Q100-B_ GND 2N3904
R257 X7 Net-_Q101-B_ 10k
R268 GND Net-_Q104-B_ 22k
R258 X3 Net-_Q102-B_ 10k
R764 Net-_Q288-C_ Net-_Q294-B_ 10k
Q294 Net-_Q294-C_ Net-_Q294-B_ GND 2N3904
R765 GND Net-_Q294-B_ 22k
R768 Net-_Q295-C_ Net-_Q297-B_ 10k
R770 +5V Net-_Q294-C_ 4.7k
R776 +5V Net-_Q297-C_ 4.7k
Q297 Net-_Q297-C_ Net-_Q297-B_ Net-_Q297-E_ 2N3904
R774 GND Net-_Q297-B_ 22k
R772 GND Net-_Q298-B_ 22k
R769 Net-_Q292-C_ Net-_Q298-B_ 10k
Q298 Net-_Q297-E_ Net-_Q298-B_ GND 2N3904
R784 GND Net-_Q301-B_ 22k
R781 Net-_Q294-C_ Net-_Q301-B_ 10k
R783 Net-_Q299-C_ Net-_Q303-B_ 10k
R782 Net-_Q294-C_ Net-_Q302-B_ 10k
R779 +5V Net-_Q299-C_ 4.7k
R787 GND Net-_Q302-B_ 22k
R777 Net-_Q295-C_ Net-_Q299-B_ 10k
R778 GND Net-_Q299-B_ 22k
Q299 Net-_Q299-C_ Net-_Q299-B_ GND 2N3904
R780 Net-_Q295-C_ Net-_Q300-B_ 10k
R786 GND Net-_Q300-B_ 22k
R785 GND Net-_Q303-B_ 22k
R762 +5V Net-_Q290-C_ 4.7k
Q296 Net-_Q295-E_ Net-_Q296-B_ GND 2N3904
R771 GND Net-_Q296-B_ 22k
R773 GND Net-_Q295-B_ 22k
R767 Net-_Q297-C_ Net-_Q296-B_ 10k
R651 Net-_Q248-C_ Net-_Q251-B_ 10k
R659 +5V Net-_Q252-C_ 4.7k
R649 +5V Net-_Q249-C_ 4.7k
R656 GND Net-_Q250-B_ 22k
Q250 Net-_Q250-C_ Net-_Q250-B_ Net-_Q250-E_ 2N3904
Q251 Net-_Q250-E_ Net-_Q251-B_ GND 2N3904
R654 GND Net-_Q251-B_ 22k
R657 GND Net-_Q252-B_ 22k
Q252 Net-_Q252-C_ Net-_Q252-B_ Net-_Q252-E_ 2N3904
R652 Net-_Q248-C_ Net-_Q252-B_ 10k
R653 Net-_Q249-C_ Net-_Q253-B_ 10k
R655 GND Net-_Q253-B_ 22k
Q253 Net-_Q252-E_ Net-_Q253-B_ GND 2N3904
R647 +5V Net-_Q248-C_ 2.2k
R644 MEMCLK Net-_Q248-B_ 10k
R658 +5V Net-_Q250-C_ 4.7k
R662 Net-_Q250-C_ Net-_Q255-B_ 10k
R663 Net-_Q257-C_ Net-_Q256-B_ 10k
R669 GND Net-_Q255-B_ 22k
Q255 Net-_Q255-C_ Net-_Q255-B_ Net-_Q255-E_ 2N3904
R671 +5V Net-_Q255-C_ 4.7k
Q256 Net-_Q255-E_ Net-_Q256-B_ GND 2N3904
R667 GND Net-_Q256-B_ 22k
Q246 Net-_Q246-C_ Net-_Q246-B_ Net-_Q246-E_ 2N3904
Q247 Net-_Q246-E_ Net-_Q247-B_ GND 2N3904
R641 GND Net-_Q246-B_ 22k
Q244 OUT_B3 Net-_Q244-B_ Net-_Q244-E_ 2N3904
R640 GND Net-_Q244-B_ 22k
R642 +5V OUT_B3 2.2k
R638 GND Net-_Q245-B_ 22k
Q245 Net-_Q244-E_ Net-_Q245-B_ GND 2N3904
R643 +5V Net-_Q246-C_ 4.7k
R639 GND Net-_Q247-B_ 22k
R672 +5V Net-_Q257-C_ 4.7k
R668 GND Net-_Q258-B_ 22k
R660 Net-_Q248-C_ Net-_Q254-B_ 10k
Q254 Net-_Q254-C_ Net-_Q254-B_ GND 2N3904
R665 Net-_Q252-C_ Net-_Q258-B_ 10k
R664 Net-_Q255-C_ Net-_Q257-B_ 10k
Q258 Net-_Q257-E_ Net-_Q258-B_ GND 2N3904
Q257 Net-_Q257-C_ Net-_Q257-B_ Net-_Q257-E_ 2N3904
R670 GND Net-_Q257-B_ 22k
R666 +5V Net-_Q254-C_ 4.7k
R650 REG_D2 Net-_Q250-B_ 10k
Q249 Net-_Q249-C_ Net-_Q249-B_ GND 2N3904
R648 GND Net-_Q249-B_ 22k
R646 REG_D2 Net-_Q249-B_ 10k
R636 OUT_B3 Net-_Q246-B_ 10k
R632 +5V Net-_Q240-C_ 4.7k
Q241 Net-_Q240-E_ Net-_Q241-B_ GND 2N3904
R628 GND Net-_Q241-B_ 22k
R630 GND Net-_Q240-B_ 22k
R624 Net-_Q235-C_ Net-_Q240-B_ 10k
Q240 Net-_Q240-C_ Net-_Q240-B_ Net-_Q240-E_ 2N3904
R625 Net-_Q234-C_ Net-_Q241-B_ 10k
R634 Net-_Q240-C_ Net-_Q244-B_ 10k
R635 Net-_Q246-C_ Net-_Q245-B_ 10k
Q243 Net-_Q242-E_ Net-_Q243-B_ GND 2N3904
Q242 Net-_Q242-C_ Net-_Q242-B_ Net-_Q242-E_ 2N3904
R637 Net-_Q242-C_ Net-_Q247-B_ 10k
R627 Net-_Q239-C_ Net-_Q243-B_ 10k
R629 GND Net-_Q243-B_ 22k
R631 GND Net-_Q242-B_ 22k
R626 Net-_Q234-C_ Net-_Q242-B_ 10k
R633 +5V Net-_Q242-C_ 4.7k
R595 +5V Net-_Q228-C_ 2.2k
R593 GND Net-_Q228-B_ 22k
R592 MEMCLK Net-_Q228-B_ 10k
Q228 Net-_Q228-C_ Net-_Q228-B_ GND 2N3904
Q229 Net-_Q229-C_ Net-_Q229-B_ GND 2N3904
R596 GND Net-_Q229-B_ 22k
Q235 Net-_Q235-C_ Net-_Q235-B_ Net-_Q235-E_ 2N3904
R612 Net-_Q235-C_ Net-_Q237-B_ 10k
R611 Net-_Q237-C_ Net-_Q236-B_ 10k
R617 GND Net-_Q235-B_ 22k
R619 +5V Net-_Q235-C_ 4.7k
R610 Net-_Q230-C_ Net-_Q235-B_ 10k
R615 GND Net-_Q236-B_ 22k
Q236 Net-_Q235-E_ Net-_Q236-B_ GND 2N3904
R620 +5V Net-_Q237-C_ 4.7k
R598 REG_D3 Net-_Q230-B_ 10k
R599 Net-_Q228-C_ Net-_Q231-B_ 10k
R604 GND Net-_Q230-B_ 22k
Q230 Net-_Q230-C_ Net-_Q230-B_ Net-_Q230-E_ 2N3904
R594 REG_D3 Net-_Q229-B_ 10k
R597 +5V Net-_Q229-C_ 4.7k
R602 GND Net-_Q231-B_ 22k
R600 Net-_Q228-C_ Net-_Q232-B_ 10k
R601 Net-_Q229-C_ Net-_Q233-B_ 10k
R603 GND Net-_Q233-B_ 22k
Q233 Net-_Q232-E_ Net-_Q233-B_ GND 2N3904
Q238 Net-_Q237-E_ Net-_Q238-B_ GND 2N3904
Q237 Net-_Q237-C_ Net-_Q237-B_ Net-_Q237-E_ 2N3904
R613 Net-_Q232-C_ Net-_Q238-B_ 10k
R618 GND Net-_Q237-B_ 22k
Q231 Net-_Q230-E_ Net-_Q231-B_ GND 2N3904
R606 +5V Net-_Q230-C_ 4.7k
R616 GND Net-_Q238-B_ 22k
R607 +5V Net-_Q232-C_ 4.7k
Q232 Net-_Q232-C_ Net-_Q232-B_ Net-_Q232-E_ 2N3904
R605 GND Net-_Q232-B_ 22k
R614 +5V Net-_Q234-C_ 4.7k
R609 GND Net-_Q234-B_ 22k
R608 Net-_Q228-C_ Net-_Q234-B_ 10k
Q234 Net-_Q234-C_ Net-_Q234-B_ GND 2N3904
R467 GND Net-_Q180-B_ 22k
R468 +5V Net-_Q180-C_ 4.7k
Q180 Net-_Q180-C_ Net-_Q180-B_ GND 2N3904
R465 +5V Net-_Q178-C_ 4.7k
R466 Net-_Q178-C_ Net-_Q180-B_ 10k
Q179 Net-_Q178-E_ Net-_Q179-B_ GND 2N3904
Q178 Net-_Q178-C_ Net-_Q178-B_ Net-_Q178-E_ 2N3904
R462 Net-_Q176-C_ Net-_Q179-B_ 10k
R461 Net-_Q175-C_ Net-_Q178-B_ 10k
R464 GND Net-_Q178-B_ 22k
R463 GND Net-_Q179-B_ 22k
R453 S0 Net-_Q176-B_ 10k
R454 SIGB Net-_Q177-B_ 10k
R456 GND Net-_Q177-B_ 22k
Q177 Net-_Q176-E_ Net-_Q177-B_ GND 2N3904
R457 GND Net-_Q176-B_ 22k
R460 +5V Net-_Q176-C_ 4.7k
Q176 Net-_Q176-C_ Net-_Q176-B_ Net-_Q176-E_ 2N3904
Q175 Net-_Q175-C_ Net-_Q175-B_ GND 2N3904
R458 GND Net-_Q175-B_ 22k
Q174 Net-_Q173-C_ Net-_Q174-B_ GND 2N3904
R450 SIGB Net-_Q174-B_ 10k
Q173 Net-_Q173-C_ Net-_Q173-B_ GND 2N3904
R449 GND Net-_Q173-B_ 22k
R448 S0 Net-_Q173-B_ 10k
R459 +5V Net-_Q175-C_ 4.7k
R455 Net-_Q173-C_ Net-_Q175-B_ 10k
R452 GND Net-_Q174-B_ 22k
R451 +5V Net-_Q173-C_ 4.7k
R554 +5V Net-_Q210-C_ 4.7k
Q210 Net-_Q210-C_ Net-_Q210-B_ Net-_Q210-E_ 2N3904
R552 GND Net-_Q210-B_ 22k
R543 +5V Net-_Q208-C_ 2.2k
R540 MEMCLK Net-_Q208-B_ 10k
R544 GND Net-_Q209-B_ 22k
Q209 Net-_Q209-C_ Net-_Q209-B_ GND 2N3904
R542 REG_DS Net-_Q209-B_ 10k
Q208 Net-_Q208-C_ Net-_Q208-B_ GND 2N3904
R541 GND Net-_Q208-B_ 22k
R556 Net-_Q208-C_ Net-_Q214-B_ 10k
R557 GND Net-_Q214-B_ 22k
Q214 Net-_Q214-C_ Net-_Q214-B_ GND 2N3904
R547 Net-_Q208-C_ Net-_Q211-B_ 10k
R546 REG_DS Net-_Q210-B_ 10k
R545 +5V Net-_Q209-C_ 4.7k
R555 +5V Net-_Q212-C_ 4.7k
Q213 Net-_Q212-E_ Net-_Q213-B_ GND 2N3904
R553 GND Net-_Q212-B_ 22k
R548 Net-_Q208-C_ Net-_Q212-B_ 10k
R551 GND Net-_Q213-B_ 22k
R549 Net-_Q209-C_ Net-_Q213-B_ 10k
Q212 Net-_Q212-C_ Net-_Q212-B_ Net-_Q212-E_ 2N3904
Q211 Net-_Q210-E_ Net-_Q211-B_ GND 2N3904
R550 GND Net-_Q211-B_ 22k
Q183 Net-_Q183-C_ Net-_Q183-B_ GND 2N3904
R479 GND Net-_Q183-B_ 22k
R476 Net-_Q181-C_ Net-_Q183-B_ 10k
R485 GND Net-_Q186-B_ 22k
R486 +5V Net-_Q186-C_ 4.7k
R474 S1 Net-_Q184-B_ 10k
R483 Net-_Q184-C_ Net-_Q187-B_ 10k
R481 +5V Net-_Q184-C_ 4.7k
R482 Net-_Q183-C_ Net-_Q186-B_ 10k
R473 GND Net-_Q182-B_ 22k
R471 SIGB Net-_Q182-B_ 10k
Q182 Net-_Q181-C_ Net-_Q182-B_ GND 2N3904
R469 S1 Net-_Q181-B_ 10k
R480 +5V Net-_Q183-C_ 4.7k
R470 GND Net-_Q181-B_ 22k
Q181 Net-_Q181-C_ Net-_Q181-B_ GND 2N3904
R472 +5V Net-_Q181-C_ 4.7k
R490 S2 Net-_Q189-B_ 10k
R492 SIGB Net-_Q190-B_ 10k
R491 GND Net-_Q189-B_ 22k
R351 GND Net-_Q136-B_ 22k
Q136 Net-_Q136-C_ Net-_Q136-B_ GND 2N3904
R365 +5V Net-_Q138-C_ 4.7k
R350 Net-_Q180-C_ Net-_Q136-B_ 10k
R353 +5V Net-_Q136-C_ 4.7k
Q184 Net-_Q184-C_ Net-_Q184-B_ Net-_Q184-E_ 2N3904
R478 GND Net-_Q184-B_ 22k
Q185 Net-_Q184-E_ Net-_Q185-B_ GND 2N3904
R477 GND Net-_Q185-B_ 22k
R475 SIGB Net-_Q185-B_ 10k
R489 +5V Net-_Q188-C_ 4.7k
R438 GND Net-_Q169-B_ 22k
Q169 Net-_Q169-C_ Net-_Q169-B_ GND 2N3904
R439 +5V Net-_Q169-C_ 4.7k
R437 S3 Net-_Q169-B_ 10k
R379 Net-_Q188-C_ Net-_Q147-B_ 10k
R488 GND Net-_Q188-B_ 22k
R487 Net-_Q186-C_ Net-_Q188-B_ 10k
Q188 Net-_Q188-C_ Net-_Q188-B_ GND 2N3904
R484 GND Net-_Q187-B_ 22k
Q186 Net-_Q186-C_ Net-_Q186-B_ Net-_Q186-E_ 2N3904
Q187 Net-_Q186-E_ Net-_Q187-B_ GND 2N3904
Q147 Net-_Q147-C_ Net-_Q147-B_ GND 2N3904
R394 +5V Net-_Q149-C_ 4.7k
R382 +5V Net-_Q147-C_ 4.7k
R387 Net-_Q143-C_ Net-_Q153-B_ 10k
R391 GND Net-_Q153-B_ 22k
Q153 Net-_Q152-E_ Net-_Q153-B_ GND 2N3904
R362 GND Net-_Q142-B_ 22k
Q143 Net-_Q143-C_ Net-_Q143-B_ GND 2N3904
Q142 Net-_Q141-E_ Net-_Q142-B_ GND 2N3904
R358 SIG Net-_Q142-B_ 10k
R366 +5V Net-_Q139-C_ 4.7k
R373 GND Net-_Q144-B_ 22k
R369 Net-_Q138-C_ Net-_Q144-B_ 10k
R375 +5V Net-_Q144-C_ 4.7k
R376 Net-_Q144-C_ Net-_Q146-B_ 10k
Q144 Net-_Q144-C_ Net-_Q144-B_ Net-_Q144-E_ 2N3904
R377 GND Net-_Q146-B_ 22k
Q146 OUT0 Net-_Q146-B_ GND 2N3904
R378 +5V OUT0 4.7k
Q145 Net-_Q144-E_ Net-_Q145-B_ GND 2N3904
R389 GND Net-_Q151-B_ 22k
Q151 Net-_Q150-E_ Net-_Q151-B_ GND 2N3904
R396 +5V Net-_Q152-C_ 4.7k
R386 Net-_Q188-C_ Net-_Q152-B_ 10k
R385 Net-_Q143-C_ Net-_Q151-B_ 10k
R393 GND Net-_Q152-B_ 22k
R397 Net-_Q152-C_ Net-_Q154-B_ 10k
Q152 Net-_Q152-C_ Net-_Q152-B_ Net-_Q152-E_ 2N3904
R399 Net-_Q150-C_ Net-_Q156-B_ 10k
R398 Net-_Q149-C_ Net-_Q155-B_ 10k
R384 Net-_Q188-C_ Net-_Q150-B_ 10k
R395 +5V Net-_Q150-C_ 4.7k
R383 GND Net-_Q148-B_ 22k
R390 GND Net-_Q150-B_ 22k
Q150 Net-_Q150-C_ Net-_Q150-B_ Net-_Q150-E_ 2N3904
R372 GND Net-_Q145-B_ 22k
R370 Net-_Q139-C_ Net-_Q145-B_ 10k
Q141 Net-_Q141-C_ Net-_Q141-B_ Net-_Q141-E_ 2N3904
R364 GND Net-_Q141-B_ 22k
R371 GND Net-_Q143-B_ 22k
R360 GND Net-_Q140-B_ 22k
Q140 Net-_Q139-E_ Net-_Q140-B_ GND 2N3904
R357 Net-_Q180-C_ Net-_Q141-B_ 10k
R356 SIG Net-_Q140-B_ 10k
R374 +5V Net-_Q143-C_ 4.7k
R367 +5V Net-_Q141-C_ 4.7k
R368 Net-_Q141-C_ Net-_Q143-B_ 10k
R363 GND Net-_Q138-B_ 22k
R359 Net-_Q136-C_ Net-_Q138-B_ 10k
Q138 Net-_Q138-C_ Net-_Q138-B_ GND 2N3904
R352 SIG Net-_Q137-B_ 10k
Q137 Net-_Q136-C_ Net-_Q137-B_ GND 2N3904
Q139 Net-_Q139-C_ Net-_Q139-B_ Net-_Q139-E_ 2N3904
R355 Net-_Q180-C_ Net-_Q139-B_ 10k
R361 GND Net-_Q139-B_ 22k
R354 GND Net-_Q137-B_ 22k
R392 GND Net-_Q149-B_ 22k
Q149 Net-_Q149-C_ Net-_Q149-B_ GND 2N3904
R388 Net-_Q147-C_ Net-_Q149-B_ 10k
R381 Net-_Q143-C_ Net-_Q148-B_ 10k
R380 GND Net-_Q147-B_ 22k
Q148 Net-_Q147-C_ Net-_Q148-B_ GND 2N3904
R562 +5V Net-_Q214-C_ 4.7k
R570 GND Net-_Q219-B_ 22k
Q219 Net-_Q219-C_ Net-_Q219-B_ GND 2N3904
R569 Net-_Q215-C_ Net-_Q219-B_ 10k
R566 GND Net-_Q217-B_ 22k
Q217 Net-_Q217-C_ Net-_Q217-B_ Net-_Q217-E_ 2N3904
Q218 Net-_Q217-E_ Net-_Q218-B_ GND 2N3904
R561 Net-_Q212-C_ Net-_Q218-B_ 10k
R564 GND Net-_Q218-B_ 22k
R568 +5V Net-_Q217-C_ 4.7k
R567 +5V Net-_Q215-C_ 4.7k
R558 Net-_Q210-C_ Net-_Q215-B_ 10k
R563 GND Net-_Q216-B_ 22k
R560 Net-_Q215-C_ Net-_Q217-B_ 10k
R559 Net-_Q217-C_ Net-_Q216-B_ 10k
R565 GND Net-_Q215-B_ 22k
Q215 Net-_Q215-C_ Net-_Q215-B_ Net-_Q215-E_ 2N3904
Q216 Net-_Q215-E_ Net-_Q216-B_ GND 2N3904
R590 +5V OUT_SIGN 2.2k
Q221 Net-_Q220-E_ Net-_Q221-B_ GND 2N3904
R576 GND Net-_Q221-B_ 22k
Q220 Net-_Q220-C_ Net-_Q220-B_ Net-_Q220-E_ 2N3904
R586 GND Net-_Q225-B_ 22k
R591 +5V Net-_Q226-C_ 4.7k
R583 Net-_Q226-C_ Net-_Q225-B_ 10k
Q224 OUT_SIGN Net-_Q224-B_ Net-_Q224-E_ 2N3904
Q225 Net-_Q224-E_ Net-_Q225-B_ GND 2N3904
R588 GND Net-_Q224-B_ 22k
R582 Net-_Q220-C_ Net-_Q224-B_ 10k
R573 Net-_Q214-C_ Net-_Q221-B_ 10k
R578 GND Net-_Q220-B_ 22k
R572 Net-_Q215-C_ Net-_Q220-B_ 10k
R580 +5V Net-_Q220-C_ 4.7k
R571 +5V Net-_Q219-C_ 4.7k
R574 Net-_Q214-C_ Net-_Q222-B_ 10k
Q222 Net-_Q222-C_ Net-_Q222-B_ Net-_Q222-E_ 2N3904
Q223 Net-_Q222-E_ Net-_Q223-B_ GND 2N3904
R579 GND Net-_Q222-B_ 22k
R581 +5V Net-_Q222-C_ 4.7k
R575 Net-_Q219-C_ Net-_Q223-B_ 10k
R577 GND Net-_Q223-B_ 22k
R585 Net-_Q222-C_ Net-_Q227-B_ 10k
R589 GND Net-_Q226-B_ 22k
R584 OUT_SIGN Net-_Q226-B_ 10k
Q226 Net-_Q226-C_ Net-_Q226-B_ Net-_Q226-E_ 2N3904
Q227 Net-_Q226-E_ Net-_Q227-B_ GND 2N3904
R587 GND Net-_Q227-B_ 22k
Q189 Net-_Q189-C_ Net-_Q189-B_ GND 2N3904
Q196 Net-_Q196-C_ Net-_Q196-B_ GND 2N3904
R509 GND Net-_Q196-B_ 22k
Q195 Net-_Q194-E_ Net-_Q195-B_ GND 2N3904
Q194 Net-_Q194-C_ Net-_Q194-B_ Net-_Q194-E_ 2N3904
R495 S2 Net-_Q192-B_ 10k
R496 SIGB Net-_Q193-B_ 10k
Q190 Net-_Q189-C_ Net-_Q190-B_ GND 2N3904
R494 GND Net-_Q190-B_ 22k
R498 GND Net-_Q193-B_ 22k
Q193 Net-_Q192-E_ Net-_Q193-B_ GND 2N3904
R504 Net-_Q192-C_ Net-_Q195-B_ 10k
R499 GND Net-_Q192-B_ 22k
Q192 Net-_Q192-C_ Net-_Q192-B_ Net-_Q192-E_ 2N3904
R505 GND Net-_Q195-B_ 22k
R501 +5V Net-_Q191-C_ 4.7k
R510 +5V Net-_Q196-C_ 4.7k
R507 +5V Net-_Q194-C_ 4.7k
R508 Net-_Q194-C_ Net-_Q196-B_ 10k
R497 Net-_Q189-C_ Net-_Q191-B_ 10k
R503 Net-_Q191-C_ Net-_Q194-B_ 10k
R502 +5V Net-_Q192-C_ 4.7k
R500 GND Net-_Q191-B_ 22k
Q191 Net-_Q191-C_ Net-_Q191-B_ GND 2N3904
R506 GND Net-_Q194-B_ 22k
R514 +5V Net-_Q197-C_ 4.7k
Q197 Net-_Q197-C_ Net-_Q197-B_ GND 2N3904
R512 GND Net-_Q197-B_ 22k
R511 S3 Net-_Q197-B_ 10k
Q199 Net-_Q199-C_ Net-_Q199-B_ GND 2N3904
R526 +5V Net-_Q199-C_ 4.7k
R520 Net-_Q197-C_ Net-_Q199-B_ 10k
R310 EB1 Net-_Q121-B_ 10k
R309 GND Net-_Q120-B_ 22k
R308 SUB2 Net-_Q120-B_ 10k
Q120 Net-_Q120-C_ Net-_Q120-B_ GND 2N3904
R315 Net-_Q120-C_ Net-_Q122-B_ 10k
R319 +5V Net-_Q122-C_ 4.7k
R311 +5V Net-_Q120-C_ 4.7k
Q122 Net-_Q122-C_ Net-_Q122-B_ GND 2N3904
R320 +5V Net-_Q123-C_ 4.7k
R321 Net-_Q122-C_ Net-_Q125-B_ 10k
R313 SUB2 Net-_Q123-B_ 10k
R317 GND Net-_Q123-B_ 22k
R322 Net-_Q123-C_ Net-_Q126-B_ 10k
Q123 Net-_Q123-C_ Net-_Q123-B_ Net-_Q123-E_ 2N3904
R318 GND Net-_Q122-B_ 22k
Q121 Net-_Q120-C_ Net-_Q121-B_ GND 2N3904
R312 GND Net-_Q121-B_ 22k
R316 GND Net-_Q124-B_ 22k
Q124 Net-_Q123-E_ Net-_Q124-B_ GND 2N3904
R314 EB1 Net-_Q124-B_ 10k
R341 +5V Net-_Q131-C_ 4.7k
R338 GND Net-_Q131-B_ 22k
Q131 Net-_Q131-C_ Net-_Q131-B_ Net-_Q131-E_ 2N3904
R344 GND Net-_Q134-B_ 22k
R345 GND Net-_Q133-B_ 22k
R335 EB2 Net-_Q132-B_ 10k
R337 GND Net-_Q132-B_ 22k
Q132 Net-_Q131-E_ Net-_Q132-B_ GND 2N3904
R334 SUB2 Net-_Q131-B_ 10k
R343 Net-_Q131-C_ Net-_Q134-B_ 10k
R342 Net-_Q130-C_ Net-_Q133-B_ 10k
R347 Net-_Q133-C_ Net-_Q135-B_ 10k
R346 +5V Net-_Q133-C_ 4.7k
Q133 Net-_Q133-C_ Net-_Q133-B_ Net-_Q133-E_ 2N3904
R348 GND Net-_Q135-B_ 22k
Q134 Net-_Q133-E_ Net-_Q134-B_ GND 2N3904
Q135 /B2 Net-_Q135-B_ GND 2N3904
R349 +5V /B2 4.7k
R332 +5V Net-_Q128-C_ 4.7k
R329 SUB2 Net-_Q128-B_ 10k
R331 EB2 Net-_Q129-B_ 10k
Q128 Net-_Q128-C_ Net-_Q128-B_ GND 2N3904
R330 GND Net-_Q128-B_ 22k
R336 Net-_Q128-C_ Net-_Q130-B_ 10k
Q130 Net-_Q130-C_ Net-_Q130-B_ GND 2N3904
R339 GND Net-_Q130-B_ 22k
R340 +5V Net-_Q130-C_ 4.7k
R333 GND Net-_Q129-B_ 22k
Q129 Net-_Q128-C_ Net-_Q129-B_ GND 2N3904
R324 GND Net-_Q125-B_ 22k
Q126 Net-_Q125-E_ Net-_Q126-B_ GND 2N3904
Q125 Net-_Q125-C_ Net-_Q125-B_ Net-_Q125-E_ 2N3904
R323 GND Net-_Q126-B_ 22k
R292 SUB2 Net-_Q115-B_ 10k
R293 EB0 Net-_Q116-B_ 10k
R291 GND Net-_Q113-B_ 22k
Q113 Net-_Q112-C_ Net-_Q113-B_ GND 2N3904
R289 EB0 Net-_Q113-B_ 10k
R326 Net-_Q125-C_ Net-_Q127-B_ 10k
Q127 /B1 Net-_Q127-B_ GND 2N3904
R328 +5V /B1 4.7k
R325 +5V Net-_Q125-C_ 4.7k
R327 GND Net-_Q127-B_ 22k
R294 Net-_Q112-C_ Net-_Q114-B_ 10k
R288 GND Net-_Q112-B_ 22k
R287 SUB2 Net-_Q112-B_ 10k
Q112 Net-_Q112-C_ Net-_Q112-B_ GND 2N3904
R290 +5V Net-_Q112-C_ 4.7k
R186 /Cin2 Net-_Q74-B_ 10k
R185 Net-_Q67-C_ Net-_Q73-B_ 10k
R190 GND Net-_Q74-B_ 22k
Q74 Net-_Q73-E_ Net-_Q74-B_ GND 2N3904
R192 GND Net-_Q73-B_ 22k
Q73 Net-_Q73-C_ Net-_Q73-B_ Net-_Q73-E_ 2N3904
R199 GND Net-_Q75-B_ 22k
R196 Net-_Q73-C_ Net-_Q75-B_ 10k
R195 +5V Net-_Q73-C_ 4.7k
R209 Net-_Q64-C_ Net-_Q80-B_ 10k
R213 GND Net-_Q81-B_ 22k
R212 Net-_Q79-C_ Net-_Q81-B_ 10k
Q81 S3 Net-_Q81-B_ GND 2N3904
Q80 Net-_Q79-C_ Net-_Q80-B_ GND 2N3904
R211 GND Net-_Q80-B_ 22k
Q79 Net-_Q79-C_ Net-_Q79-B_ GND 2N3904
R208 GND Net-_Q79-B_ 22k
R207 Net-_Q75-C_ Net-_Q79-B_ 10k
R210 +5V Net-_Q79-C_ 4.7k
Q78 S2 Net-_Q78-B_ GND 2N3904
R205 GND Net-_Q78-B_ 22k
R214 +5V S3 2.2k
R182 GND Net-_Q69-B_ 22k
R188 GND Net-_Q72-B_ 22k
Q72 Net-_Q71-E_ Net-_Q72-B_ GND 2N3904
R184 /Cin2 Net-_Q72-B_ 10k
R183 Net-_Q67-C_ Net-_Q71-B_ 10k
Q69 Net-_Q68-C_ Net-_Q69-B_ GND 2N3904
R194 +5V Net-_Q71-C_ 4.7k
Q75 Net-_Q75-C_ Net-_Q75-B_ GND 2N3904
R202 +5V Net-_Q75-C_ 4.7k
R197 Net-_Q70-C_ Net-_Q76-B_ 10k
R198 Net-_Q71-C_ Net-_Q77-B_ 10k
Q77 Net-_Q76-E_ Net-_Q77-B_ GND 2N3904
Q76 Net-_Q76-C_ Net-_Q76-B_ Net-_Q76-E_ 2N3904
R201 GND Net-_Q76-B_ 22k
Q71 Net-_Q71-C_ Net-_Q71-B_ Net-_Q71-E_ 2N3904
R189 GND Net-_Q71-B_ 22k
R204 Net-_Q76-C_ Net-_Q78-B_ 10k
R200 GND Net-_Q77-B_ 22k
R152 +5V Net-_Q57-C_ 4.7k
Q57 Net-_Q57-C_ Net-_Q57-B_ GND 2N3904
R149 A2 Net-_Q57-B_ 10k
R164 +5V Net-_Q59-C_ 4.7k
R295 GND Net-_Q116-B_ 22k
Q116 Net-_Q115-E_ Net-_Q116-B_ GND 2N3904
R301 Net-_Q115-C_ Net-_Q118-B_ 10k
R299 +5V Net-_Q115-C_ 4.7k
R300 Net-_Q114-C_ Net-_Q117-B_ 10k
R297 GND Net-_Q114-B_ 22k
R298 +5V Net-_Q114-C_ 4.7k
Q114 Net-_Q114-C_ Net-_Q114-B_ GND 2N3904
Q115 Net-_Q115-C_ Net-_Q115-B_ Net-_Q115-E_ 2N3904
R296 GND Net-_Q115-B_ 22k
R302 GND Net-_Q118-B_ 22k
R305 Net-_Q117-C_ Net-_Q119-B_ 10k
R306 GND Net-_Q119-B_ 22k
R303 GND Net-_Q117-B_ 22k
Q118 Net-_Q117-E_ Net-_Q118-B_ GND 2N3904
Q117 Net-_Q117-C_ Net-_Q117-B_ Net-_Q117-E_ 2N3904
R304 +5V Net-_Q117-C_ 4.7k
R181 +5V Net-_Q68-C_ 4.7k
R178 Net-_Q67-C_ Net-_Q68-B_ 10k
R307 +5V /B0 4.7k
Q119 /B0 Net-_Q119-B_ GND 2N3904
R206 +5V S2 2.2k
R203 +5V Net-_Q76-C_ 4.7k
Q70 Net-_Q70-C_ Net-_Q70-B_ GND 2N3904
Q68 Net-_Q68-C_ Net-_Q68-B_ GND 2N3904
R179 GND Net-_Q68-B_ 22k
R180 /Cin2 Net-_Q69-B_ 10k
R177 +5V Net-_Q67-C_ 4.7k
R174 +5V Net-_Q65-C_ 4.7k
R175 Net-_Q65-C_ Net-_Q67-B_ 10k
R187 Net-_Q68-C_ Net-_Q70-B_ 10k
R193 +5V Net-_Q70-C_ 4.7k
R191 GND Net-_Q70-B_ 22k
R173 +5V Net-_Q64-C_ 4.7k
R166 +5V Net-_Q62-C_ 4.7k
R167 Net-_Q62-C_ Net-_Q64-B_ 10k
Q65 Net-_Q65-C_ Net-_Q65-B_ Net-_Q65-E_ 2N3904
Q66 Net-_Q65-E_ Net-_Q66-B_ GND 2N3904
Q67 Net-_Q67-C_ Net-_Q67-B_ GND 2N3904
R176 GND Net-_Q67-B_ 22k
R163 GND Net-_Q62-B_ 22k
R493 +5V Net-_Q189-C_ 4.7k
R161 GND Net-_Q63-B_ 22k
Q63 Net-_Q62-E_ Net-_Q63-B_ GND 2N3904
Q62 Net-_Q62-C_ Net-_Q62-B_ Net-_Q62-E_ 2N3904
R157 /B2 Net-_Q63-B_ 10k
R156 A2 Net-_Q62-B_ 10k
R170 GND Net-_Q64-B_ 22k
Q64 Net-_Q64-C_ Net-_Q64-B_ GND 2N3904
Q60 Net-_Q60-C_ Net-_Q60-B_ Net-_Q60-E_ 2N3904
Q61 Net-_Q60-E_ Net-_Q61-B_ GND 2N3904
R160 GND Net-_Q60-B_ 22k
R159 GND Net-_Q61-B_ 22k
R172 GND Net-_Q65-B_ 22k
R171 GND Net-_Q66-B_ 22k
R155 /B2 Net-_Q61-B_ 10k
R165 +5V Net-_Q60-C_ 4.7k
R169 Net-_Q60-C_ Net-_Q66-B_ 10k
R154 A2 Net-_Q60-B_ 10k
Q58 Net-_Q57-C_ Net-_Q58-B_ GND 2N3904
Q59 Net-_Q59-C_ Net-_Q59-B_ GND 2N3904
R168 Net-_Q59-C_ Net-_Q65-B_ 10k
R162 GND Net-_Q59-B_ 22k
R150 GND Net-_Q57-B_ 22k
R151 /B2 Net-_Q58-B_ 10k
R153 GND Net-_Q58-B_ 22k
R158 Net-_Q57-C_ Net-_Q59-B_ 10k
Q401 Net-_Q400-E_ Net-_Q401-B_ Net-_Q401-E_ 2N3904
R1048 GND Net-_Q401-B_ 22k
R1095 GND Net-_Q423-B_ 22k
Q423 /F_OUT11 Net-_Q423-B_ GND 2N3904
R1103 +5V /F_OUT11 4.7k
R1090 Net-_Q400-C_ Net-_Q423-B_ 10k
R1079 +5V Net-_Q400-C_ 4.7k
R1051 GND Net-_Q400-B_ 22k
Q400 Net-_Q400-C_ Net-_Q400-B_ Net-_Q400-E_ 2N3904
R1032 OUT_B3 Net-_Q400-B_ 10k
R1033 Net-_Q375-C_ Net-_Q401-B_ 10k
Q402 Net-_Q401-E_ Net-_Q402-B_ Net-_Q402-E_ 2N3904
R1049 GND Net-_Q402-B_ 22k
Q375 Net-_Q375-C_ Net-_Q375-B_ GND 2N3904
R978 GND Net-_Q375-B_ 22k
R977 OUT_B2 Net-_Q375-B_ 10k
R979 +5V Net-_Q375-C_ 4.7k
R1034 OUT_B1 Net-_Q402-B_ 10k
R1035 OUT_B0 Net-_Q403-B_ 10k
R1050 GND Net-_Q403-B_ 22k
Q403 Net-_Q402-E_ Net-_Q403-B_ GND 2N3904
R976 +5V Net-_Q374-C_ 4.7k
R1026 OUT_B1 Net-_Q398-B_ 10k
R1027 Net-_Q374-C_ Net-_Q399-B_ 10k
R973 +5V Net-_Q373-C_ 4.7k
Q373 Net-_Q373-C_ Net-_Q373-B_ GND 2N3904
R972 GND Net-_Q373-B_ 22k
R971 OUT_B2 Net-_Q373-B_ 10k
R1042 GND Net-_Q399-B_ 22k
Q374 Net-_Q374-C_ Net-_Q374-B_ GND 2N3904
R975 GND Net-_Q374-B_ 22k
R974 OUT_B0 Net-_Q374-B_ 10k
R1025 Net-_Q373-C_ Net-_Q397-B_ 10k
R1040 GND Net-_Q397-B_ 22k
Q397 Net-_Q396-E_ Net-_Q397-B_ Net-_Q397-E_ 2N3904
R1024 OUT_B3 Net-_Q396-B_ 10k
Q399 Net-_Q398-E_ Net-_Q399-B_ GND 2N3904
R1041 GND Net-_Q398-B_ 22k
Q398 Net-_Q397-E_ Net-_Q398-B_ Net-_Q398-E_ 2N3904
R1043 GND Net-_Q396-B_ 22k
Q396 Net-_Q396-C_ Net-_Q396-B_ Net-_Q396-E_ 2N3904
R1091 GND Net-_Q422-B_ 22k
R1100 +5V /F_OUT10 4.7k
R1070 +5V Net-_Q396-C_ 4.7k
R1086 Net-_Q396-C_ Net-_Q422-B_ 10k
Q422 /F_OUT10 Net-_Q422-B_ GND 2N3904
R936 GND Net-_Q361-B_ 22k
R935 OUT_B1 Net-_Q361-B_ 10k
Q361 Net-_Q361-C_ Net-_Q361-B_ GND 2N3904
R937 +5V Net-_Q361-C_ 4.7k
Q360 Net-_Q360-C_ Net-_Q360-B_ GND 2N3904
R933 GND Net-_Q360-B_ 22k
R932 OUT_B3 Net-_Q360-B_ 10k
R850 Net-_Q362-C_ Net-_Q330-B_ 10k
R848 Net-_Q360-C_ Net-_Q328-B_ 10k
R863 GND Net-_Q328-B_ 22k
R849 Net-_Q361-C_ Net-_Q329-B_ 10k
R860 GND Net-_Q329-B_ 22k
Q329 Net-_Q328-E_ Net-_Q329-B_ Net-_Q329-E_ 2N3904
Q330 Net-_Q329-E_ Net-_Q330-B_ Net-_Q330-E_ 2N3904
R861 GND Net-_Q330-B_ 22k
Q363 Net-_Q363-C_ Net-_Q363-B_ GND 2N3904
R942 GND Net-_Q363-B_ 22k
R941 OUT_B3 Net-_Q363-B_ 10k
R851 OUT_B2 Net-_Q331-B_ 10k
Q331 Net-_Q330-E_ Net-_Q331-B_ GND 2N3904
R940 +5V Net-_Q362-C_ 4.7k
R862 GND Net-_Q331-B_ 22k
R939 GND Net-_Q362-B_ 22k
Q362 Net-_Q362-C_ Net-_Q362-B_ GND 2N3904
R938 OUT_B0 Net-_Q362-B_ 10k
R881 +5V Net-_Q332-C_ 4.7k
R893 +5V /F_OUT5 4.7k
Q345 /F_OUT5 Net-_Q345-B_ GND 2N3904
R885 Net-_Q332-C_ Net-_Q345-B_ 10k
R888 GND Net-_Q345-B_ 22k
R852 Net-_Q363-C_ Net-_Q332-B_ 10k
R943 +5V Net-_Q363-C_ 4.7k
Q328 Net-_Q328-C_ Net-_Q328-B_ Net-_Q328-E_ 2N3904
R886 GND Net-_Q344-B_ 22k
R891 +5V /F_OUT4 4.7k
R883 Net-_Q328-C_ Net-_Q344-B_ 10k
R880 +5V Net-_Q328-C_ 4.7k
Q344 /F_OUT4 Net-_Q344-B_ GND 2N3904
R944 OUT_B1 Net-_Q364-B_ 10k
R945 GND Net-_Q364-B_ 22k
Q364 Net-_Q364-C_ Net-_Q364-B_ GND 2N3904
R946 +5V Net-_Q364-C_ 4.7k
R868 GND Net-_Q333-B_ 22k
Q334 Net-_Q333-E_ Net-_Q334-B_ Net-_Q334-E_ 2N3904
R854 Net-_Q364-C_ Net-_Q334-B_ 10k
R869 GND Net-_Q334-B_ 22k
R855 OUT_B0 Net-_Q335-B_ 10k
Q333 Net-_Q332-E_ Net-_Q333-B_ Net-_Q333-E_ 2N3904
R853 OUT_B2 Net-_Q333-B_ 10k
R871 GND Net-_Q332-B_ 22k
Q332 Net-_Q332-C_ Net-_Q332-B_ Net-_Q332-E_ 2N3904
R980 OUT_B1 Net-_Q376-B_ 10k
Q376 Net-_Q376-C_ Net-_Q376-B_ GND 2N3904
R981 GND Net-_Q376-B_ 22k
R982 +5V Net-_Q376-C_ 4.7k
Q425 /F_OUT13 Net-_Q425-B_ GND 2N3904
R1104 GND Net-_Q425-B_ 22k
R1052 OUT_B3 Net-_Q408-B_ 10k
R1109 +5V /F_OUT13 4.7k
R1092 +5V Net-_Q408-C_ 4.7k
Q408 Net-_Q408-C_ Net-_Q408-B_ Net-_Q408-E_ 2N3904
R1099 Net-_Q408-C_ Net-_Q425-B_ 10k
R1075 GND Net-_Q408-B_ 22k
Q410 Net-_Q409-E_ Net-_Q410-B_ Net-_Q410-E_ 2N3904
R1054 Net-_Q378-C_ Net-_Q410-B_ 10k
R1072 GND Net-_Q410-B_ 22k
R1071 GND Net-_Q409-B_ 22k
R1053 OUT_B2 Net-_Q409-B_ 10k
Q409 Net-_Q408-E_ Net-_Q409-B_ Net-_Q409-E_ 2N3904
Q411 Net-_Q410-E_ Net-_Q411-B_ GND 2N3904
R1073 GND Net-_Q411-B_ 22k
R1055 OUT_B0 Net-_Q411-B_ 10k
Q407 Net-_Q406-E_ Net-_Q407-B_ GND 2N3904
R1063 GND Net-_Q407-B_ 22k
R1046 Net-_Q376-C_ Net-_Q406-B_ 10k
R1047 Net-_Q377-C_ Net-_Q407-B_ 10k
Q406 Net-_Q405-E_ Net-_Q406-B_ Net-_Q406-E_ 2N3904
R1062 GND Net-_Q406-B_ 22k
R985 +5V Net-_Q377-C_ 4.7k
Q404 Net-_Q404-C_ Net-_Q404-B_ Net-_Q404-E_ 2N3904
Q424 /F_OUT12 Net-_Q424-B_ GND 2N3904
R1101 GND Net-_Q424-B_ 22k
R1061 GND Net-_Q405-B_ 22k
Q405 Net-_Q404-E_ Net-_Q405-B_ Net-_Q405-E_ 2N3904
R1065 GND Net-_Q404-B_ 22k
R1044 OUT_B3 Net-_Q404-B_ 10k
R1045 OUT_B2 Net-_Q405-B_ 10k
R1107 +5V /F_OUT12 4.7k
R1096 Net-_Q404-C_ Net-_Q424-B_ 10k
R1088 +5V Net-_Q404-C_ 4.7k
R986 OUT_B1 Net-_Q378-B_ 10k
Q378 Net-_Q378-C_ Net-_Q378-B_ GND 2N3904
R987 GND Net-_Q378-B_ 22k
R988 +5V Net-_Q378-C_ 4.7k
Q377 Net-_Q377-C_ Net-_Q377-B_ GND 2N3904
R984 GND Net-_Q377-B_ 22k
R983 OUT_B0 Net-_Q377-B_ 10k
R830 GND Net-_Q321-B_ 22k
R924 GND Net-_Q357-B_ 22k
Q357 Net-_Q357-C_ Net-_Q357-B_ GND 2N3904
R928 +5V Net-_Q358-C_ 4.7k
Q358 Net-_Q358-C_ Net-_Q358-B_ GND 2N3904
R926 OUT_B3 Net-_Q358-B_ 10k
R923 OUT_B0 Net-_Q357-B_ 10k
R920 OUT_B2 Net-_Q356-B_ 10k
R925 +5V Net-_Q357-C_ 4.7k
Q321 Net-_Q320-E_ Net-_Q321-B_ GND 2N3904
R827 Net-_Q357-C_ Net-_Q321-B_ 10k
Q355 Net-_Q355-C_ Net-_Q355-B_ GND 2N3904
R918 GND Net-_Q355-B_ 22k
R917 OUT_B3 Net-_Q355-B_ 10k
Q356 Net-_Q356-C_ Net-_Q356-B_ GND 2N3904
R921 GND Net-_Q356-B_ 22k
R922 +5V Net-_Q356-C_ 4.7k
Q320 Net-_Q319-E_ Net-_Q320-B_ Net-_Q320-E_ 2N3904
R829 GND Net-_Q320-B_ 22k
R826 OUT_B1 Net-_Q320-B_ 10k
R844 +5V Net-_Q323-C_ 4.7k
R845 Net-_Q323-C_ Net-_Q327-B_ 10k
R836 Net-_Q358-C_ Net-_Q323-B_ 10k
Q327 /F_OUT3 Net-_Q327-B_ GND 2N3904
R847 +5V /F_OUT3 4.7k
R837 Net-_Q359-C_ Net-_Q324-B_ 10k
R840 GND Net-_Q324-B_ 22k
R846 GND Net-_Q327-B_ 22k
Q323 Net-_Q323-C_ Net-_Q323-B_ Net-_Q323-E_ 2N3904
R843 GND Net-_Q323-B_ 22k
Q324 Net-_Q323-E_ Net-_Q324-B_ Net-_Q324-E_ 2N3904
R927 GND Net-_Q358-B_ 22k
R931 +5V Net-_Q359-C_ 4.7k
Q359 Net-_Q359-C_ Net-_Q359-B_ GND 2N3904
R930 GND Net-_Q359-B_ 22k
R838 OUT_B1 Net-_Q325-B_ 10k
R841 GND Net-_Q325-B_ 22k
Q325 Net-_Q324-E_ Net-_Q325-B_ Net-_Q325-E_ 2N3904
R934 +5V Net-_Q360-C_ 4.7k
R929 OUT_B2 Net-_Q359-B_ 10k
Q326 Net-_Q325-E_ Net-_Q326-B_ GND 2N3904
R839 OUT_B0 Net-_Q326-B_ 10k
R842 GND Net-_Q326-B_ 22k
R834 GND Net-_Q322-B_ 22k
Q318 Net-_Q318-C_ Net-_Q318-B_ Net-_Q318-E_ 2N3904
R828 GND Net-_Q319-B_ 22k
Q319 Net-_Q318-E_ Net-_Q319-B_ Net-_Q319-E_ 2N3904
R824 Net-_Q355-C_ Net-_Q318-B_ 10k
R825 Net-_Q356-C_ Net-_Q319-B_ 10k
R831 GND Net-_Q318-B_ 22k
R832 +5V Net-_Q318-C_ 4.7k
R833 Net-_Q318-C_ Net-_Q322-B_ 10k
R835 +5V /F_OUT2 4.7k
Q322 /F_OUT2 Net-_Q322-B_ GND 2N3904
R870 GND Net-_Q335-B_ 22k
Q367 Net-_Q367-C_ Net-_Q367-B_ GND 2N3904
R954 GND Net-_Q367-B_ 22k
R953 OUT_B3 Net-_Q367-B_ 10k
Q342 Net-_Q341-E_ Net-_Q342-B_ Net-_Q342-E_ 2N3904
R877 GND Net-_Q342-B_ 22k
R955 +5V Net-_Q367-C_ 4.7k
Q343 Net-_Q342-E_ Net-_Q343-B_ GND 2N3904
R878 GND Net-_Q343-B_ 22k
Q341 Net-_Q340-E_ Net-_Q341-B_ Net-_Q341-E_ 2N3904
R876 GND Net-_Q341-B_ 22k
R865 OUT_B2 Net-_Q341-B_ 10k
R866 OUT_B1 Net-_Q342-B_ 10k
R867 OUT_B0 Net-_Q343-B_ 10k
Q338 Net-_Q337-E_ Net-_Q338-B_ Net-_Q338-E_ 2N3904
R873 GND Net-_Q338-B_ 22k
R872 GND Net-_Q337-B_ 22k
R857 OUT_B2 Net-_Q337-B_ 10k
R858 OUT_B1 Net-_Q338-B_ 10k
R947 OUT_B3 Net-_Q365-B_ 10k
R952 +5V Net-_Q366-C_ 4.7k
R948 GND Net-_Q365-B_ 22k
Q365 Net-_Q365-C_ Net-_Q365-B_ GND 2N3904
R856 Net-_Q365-C_ Net-_Q336-B_ 10k
R949 +5V Net-_Q365-C_ 4.7k
Q336 Net-_Q336-C_ Net-_Q336-B_ Net-_Q336-E_ 2N3904
Q337 Net-_Q336-E_ Net-_Q337-B_ Net-_Q337-E_ 2N3904
R875 GND Net-_Q336-B_ 22k
R951 GND Net-_Q366-B_ 22k
Q366 Net-_Q366-C_ Net-_Q366-B_ GND 2N3904
R950 OUT_B0 Net-_Q366-B_ 10k
R859 Net-_Q366-C_ Net-_Q339-B_ 10k
R889 Net-_Q340-C_ Net-_Q347-B_ 10k
Q347 /F_OUT7 Net-_Q347-B_ GND 2N3904
R864 Net-_Q367-C_ Net-_Q340-B_ 10k
R895 +5V /F_OUT7 4.7k
Q339 Net-_Q338-E_ Net-_Q339-B_ GND 2N3904
R874 GND Net-_Q339-B_ 22k
R892 GND Net-_Q347-B_ 22k
Q340 Net-_Q340-C_ Net-_Q340-B_ Net-_Q340-E_ 2N3904
R879 GND Net-_Q340-B_ 22k
R884 +5V Net-_Q340-C_ 4.7k
R887 Net-_Q336-C_ Net-_Q346-B_ 10k
R882 +5V Net-_Q336-C_ 4.7k
Q335 Net-_Q334-E_ Net-_Q335-B_ GND 2N3904
R894 +5V /F_OUT6 4.7k
R890 GND Net-_Q346-B_ 22k
Q346 /F_OUT6 Net-_Q346-B_ GND 2N3904
R1037 GND Net-_Q394-B_ 22k
R1023 OUT_B0 Net-_Q395-B_ 10k
R1038 GND Net-_Q395-B_ 22k
Q395 Net-_Q394-E_ Net-_Q395-B_ GND 2N3904
R968 OUT_B1 Net-_Q372-B_ 10k
R965 OUT_B2 Net-_Q371-B_ 10k
Q371 Net-_Q371-C_ Net-_Q371-B_ GND 2N3904
R966 GND Net-_Q371-B_ 22k
R967 +5V Net-_Q371-C_ 4.7k
R969 GND Net-_Q372-B_ 22k
Q372 Net-_Q372-C_ Net-_Q372-B_ GND 2N3904
R970 +5V Net-_Q372-C_ 4.7k
Q370 Net-_Q370-C_ Net-_Q370-B_ GND 2N3904
R964 +5V Net-_Q370-C_ 4.7k
R963 GND Net-_Q370-B_ 22k
R962 OUT_B0 Net-_Q370-B_ 10k
R1064 +5V Net-_Q392-C_ 4.7k
R1081 Net-_Q392-C_ Net-_Q421-B_ 10k
R1098 +5V /F_OUT9 4.7k
Q394 Net-_Q393-E_ Net-_Q394-B_ Net-_Q394-E_ 2N3904
R1022 Net-_Q372-C_ Net-_Q394-B_ 10k
R1036 GND Net-_Q393-B_ 22k
Q393 Net-_Q392-E_ Net-_Q393-B_ Net-_Q393-E_ 2N3904
R1020 OUT_B3 Net-_Q392-B_ 10k
R1021 Net-_Q371-C_ Net-_Q393-B_ 10k
R1039 GND Net-_Q392-B_ 22k
Q392 Net-_Q392-C_ Net-_Q392-B_ Net-_Q392-E_ 2N3904
R1089 GND Net-_Q421-B_ 22k
Q421 /F_OUT9 Net-_Q421-B_ GND 2N3904
R1030 GND Net-_Q391-B_ 22k
R1019 Net-_Q370-C_ Net-_Q391-B_ 10k
Q391 Net-_Q390-E_ Net-_Q391-B_ GND 2N3904
R1029 GND Net-_Q390-B_ 22k
Q390 Net-_Q389-E_ Net-_Q390-B_ Net-_Q390-E_ 2N3904
R1018 Net-_Q369-C_ Net-_Q390-B_ 10k
R1017 Net-_Q368-C_ Net-_Q389-B_ 10k
R1028 GND Net-_Q389-B_ 22k
Q389 Net-_Q388-E_ Net-_Q389-B_ Net-_Q389-E_ 2N3904
Q388 Net-_Q388-C_ Net-_Q388-B_ Net-_Q388-E_ 2N3904
R1031 GND Net-_Q388-B_ 22k
R1016 OUT_B3 Net-_Q388-B_ 10k
R1074 Net-_Q388-C_ Net-_Q416-B_ 10k
Q416 /F_OUT8 Net-_Q416-B_ GND 2N3904
R1085 GND Net-_Q416-B_ 22k
R961 +5V Net-_Q369-C_ 4.7k
Q369 Net-_Q369-C_ Net-_Q369-B_ GND 2N3904
R956 OUT_B2 Net-_Q368-B_ 10k
Q368 Net-_Q368-C_ Net-_Q368-B_ GND 2N3904
R957 GND Net-_Q368-B_ 22k
R960 GND Net-_Q369-B_ 22k
R959 OUT_B1 Net-_Q369-B_ 10k
R823 +5V /F_OUT1 4.7k
R820 +5V Net-_Q313-C_ 4.7k
R821 Net-_Q313-C_ Net-_Q317-B_ 10k
R819 GND Net-_Q313-B_ 22k
Q313 Net-_Q313-C_ Net-_Q313-B_ Net-_Q313-E_ 2N3904
R812 Net-_Q352-C_ Net-_Q313-B_ 10k
R822 GND Net-_Q317-B_ 22k
R914 OUT_B1 Net-_Q354-B_ 10k
R916 +5V Net-_Q354-C_ 4.7k
R919 +5V Net-_Q355-C_ 4.7k
R915 GND Net-_Q354-B_ 22k
Q354 Net-_Q354-C_ Net-_Q354-B_ GND 2N3904
R912 GND Net-_Q353-B_ 22k
Q353 Net-_Q353-C_ Net-_Q353-B_ GND 2N3904
R911 OUT_B2 Net-_Q353-B_ 10k
R907 +5V Net-_Q351-C_ 4.7k
R811 GND Net-_Q312-B_ 22k
Q312 Net-_Q311-E_ Net-_Q312-B_ GND 2N3904
R810 Net-_Q351-C_ Net-_Q312-B_ 10k
Q350 Net-_Q350-C_ Net-_Q350-B_ GND 2N3904
R903 GND Net-_Q350-B_ 22k
R899 OUT_B1 Net-_Q349-B_ 10k
R902 OUT_B2 Net-_Q350-B_ 10k
Q351 Net-_Q351-C_ Net-_Q351-B_ GND 2N3904
R906 GND Net-_Q351-B_ 22k
R905 OUT_B3 Net-_Q351-B_ 10k
Q349 Net-_Q349-C_ Net-_Q349-B_ GND 2N3904
R900 GND Net-_Q349-B_ 22k
R901 +5V Net-_Q349-C_ 4.7k
Q311 Net-_Q309-E_ Net-_Q311-B_ Net-_Q311-E_ 2N3904
R808 Net-_Q350-C_ Net-_Q311-B_ 10k
R809 GND Net-_Q311-B_ 22k
R904 +5V Net-_Q350-C_ 4.7k
Q309 Net-_Q308-E_ Net-_Q309-B_ Net-_Q309-E_ 2N3904
R802 GND Net-_Q309-B_ 22k
R801 Net-_Q349-C_ Net-_Q309-B_ 10k
R804 +5V Net-_Q308-C_ 4.7k
R805 Net-_Q308-C_ Net-_Q310-B_ 10k
R806 GND Net-_Q310-B_ 22k
Q310 /F_OUT0 Net-_Q310-B_ GND 2N3904
Q308 Net-_Q308-C_ Net-_Q308-B_ Net-_Q308-E_ 2N3904
R803 GND Net-_Q308-B_ 22k
R800 Net-_Q348-C_ Net-_Q308-B_ 10k
R908 OUT_B3 Net-_Q352-B_ 10k
R909 GND Net-_Q352-B_ 22k
Q352 Net-_Q352-C_ Net-_Q352-B_ GND 2N3904
R910 +5V Net-_Q352-C_ 4.7k
R913 +5V Net-_Q353-C_ 4.7k
Q317 /F_OUT1 Net-_Q317-B_ GND 2N3904
Q315 Net-_Q314-E_ Net-_Q315-B_ Net-_Q315-E_ 2N3904
R814 OUT_B0 Net-_Q315-B_ 10k
Q316 Net-_Q315-E_ Net-_Q316-B_ GND 2N3904
R818 GND Net-_Q316-B_ 22k
R817 GND Net-_Q315-B_ 22k
R815 Net-_Q354-C_ Net-_Q316-B_ 10k
R813 Net-_Q353-C_ Net-_Q314-B_ 10k
R816 GND Net-_Q314-B_ 22k
Q314 Net-_Q313-E_ Net-_Q314-B_ Net-_Q314-E_ 2N3904
R991 +5V Net-_Q379-C_ 4.7k
R990 GND Net-_Q379-B_ 22k
R989 OUT_B0 Net-_Q379-B_ 10k
Q379 Net-_Q379-C_ Net-_Q379-B_ GND 2N3904
R1087 GND Net-_Q417-B_ 22k
Q417 Net-_Q417-C_ Net-_Q417-B_ Net-_Q417-E_ 2N3904
R1097 +5V Net-_Q417-C_ 4.7k
R1111 +5V /F_OUT15 4.7k
R1108 GND Net-_Q427-B_ 22k
R1105 Net-_Q417-C_ Net-_Q427-B_ 10k
Q427 /F_OUT15 Net-_Q427-B_ GND 2N3904
R1093 +5V Net-_Q412-C_ 4.7k
R1102 Net-_Q412-C_ Net-_Q426-B_ 10k
Q426 /F_OUT14 Net-_Q426-B_ GND 2N3904
R1110 +5V /F_OUT14 4.7k
R1058 OUT_B2 Net-_Q413-B_ 10k
R1057 OUT_B3 Net-_Q412-B_ 10k
R1080 GND Net-_Q412-B_ 22k
R1106 GND Net-_Q426-B_ 22k
Q412 Net-_Q412-C_ Net-_Q412-B_ Net-_Q412-E_ 2N3904
Q413 Net-_Q412-E_ Net-_Q413-B_ Net-_Q413-E_ 2N3904
R1076 GND Net-_Q413-B_ 22k
R1083 GND Net-_Q419-B_ 22k
Q419 Net-_Q418-E_ Net-_Q419-B_ Net-_Q419-E_ 2N3904
R1068 OUT_B1 Net-_Q419-B_ 10k
Q420 Net-_Q419-E_ Net-_Q420-B_ GND 2N3904
R1084 GND Net-_Q420-B_ 22k
R1066 OUT_B3 Net-_Q417-B_ 10k
Q418 Net-_Q417-E_ Net-_Q418-B_ Net-_Q418-E_ 2N3904
R1082 GND Net-_Q418-B_ 22k
R1067 OUT_B2 Net-_Q418-B_ 10k
R1069 OUT_B0 Net-_Q420-B_ 10k
R1078 GND Net-_Q415-B_ 22k
Q414 Net-_Q413-E_ Net-_Q414-B_ Net-_Q414-E_ 2N3904
Q415 Net-_Q414-E_ Net-_Q415-B_ GND 2N3904
R1077 GND Net-_Q414-B_ 22k
R1059 OUT_B1 Net-_Q414-B_ 10k
R1060 Net-_Q379-C_ Net-_Q415-B_ 10k
R50 GND Net-_Q19-B_ 22k
R48 SUB Net-_Q19-B_ 10k
R47 GND Net-_Q18-B_ 22k
Q19 Net-_Q18-C_ Net-_Q19-B_ GND 2N3904
R55 Net-_Q18-C_ Net-_Q20-B_ 10k
R59 GND Net-_Q20-B_ 22k
R33 GND Net-_Q12-B_ 22k
R20 /B0 Net-_Q8-B_ 10k
Q8 Net-_Q7-C_ Net-_Q8-B_ GND 2N3904
R22 GND Net-_Q8-B_ 22k
R30 Net-_Q9-C_ Net-_Q12-B_ 10k
Q9 Net-_Q9-C_ Net-_Q9-B_ GND 2N3904
R23 Net-_Q7-C_ Net-_Q9-B_ 10k
R24 GND Net-_Q9-B_ 22k
R29 +5V Net-_Q10-C_ 4.7k
Q10 Net-_Q10-C_ Net-_Q10-B_ Net-_Q10-E_ 2N3904
R6 A0 Net-_Q10-B_ 10k
R37 +5V Net-_Q14-C_ 4.7k
R31 Net-_Q10-C_ Net-_Q13-B_ 10k
R34 +5V Net-_Q12-C_ 4.7k
R35 Net-_Q12-C_ Net-_Q14-B_ 10k
Q14 Net-_Q14-C_ Net-_Q14-B_ GND 2N3904
R36 GND Net-_Q14-B_ 22k
R32 GND Net-_Q13-B_ 22k
Q13 Net-_Q12-E_ Net-_Q13-B_ GND 2N3904
Q12 Net-_Q12-C_ Net-_Q12-B_ Net-_Q12-E_ 2N3904
Q11 Net-_Q10-E_ Net-_Q11-B_ GND 2N3904
R27 GND Net-_Q11-B_ 22k
R38 A0 Net-_Q15-B_ 10k
R41 GND Net-_Q15-B_ 22k
R45 +5V Net-_Q17-C_ 4.7k
R28 GND Net-_Q10-B_ 22k
R26 /B0 Net-_Q11-B_ 10k
R42 +5V Net-_Q15-C_ 4.7k
Q15 Net-_Q15-C_ Net-_Q15-B_ Net-_Q15-E_ 2N3904
R43 Net-_Q15-C_ Net-_Q17-B_ 10k
R44 GND Net-_Q17-B_ 22k
R39 /B0 Net-_Q16-B_ 10k
R40 GND Net-_Q16-B_ 22k
Q16 Net-_Q15-E_ Net-_Q16-B_ GND 2N3904
Q17 Net-_Q17-C_ Net-_Q17-B_ GND 2N3904
R52 SUB Net-_Q22-B_ 10k
R54 SUB Net-_Q24-B_ 10k
R60 GND Net-_Q23-B_ 22k
R58 GND Net-_Q24-B_ 22k
R57 GND Net-_Q21-B_ 22k
R51 Net-_Q14-C_ Net-_Q21-B_ 10k
R86 +5V Net-_Q32-C_ 4.7k
R83 A1 Net-_Q32-B_ 10k
Q32 Net-_Q32-C_ Net-_Q32-B_ GND 2N3904
R85 /B1 Net-_Q33-B_ 10k
R84 GND Net-_Q32-B_ 22k
R87 GND Net-_Q33-B_ 22k
R56 GND Net-_Q22-B_ 22k
R65 Net-_Q20-C_ Net-_Q26-B_ 10k
Q26 Net-_Q26-C_ Net-_Q26-B_ Net-_Q26-E_ 2N3904
Q27 Net-_Q26-E_ Net-_Q27-B_ GND 2N3904
Q22 Net-_Q21-E_ Net-_Q22-B_ GND 2N3904
Q21 Net-_Q21-C_ Net-_Q21-B_ Net-_Q21-E_ 2N3904
R62 +5V Net-_Q21-C_ 4.7k
R68 GND Net-_Q27-B_ 22k
R66 Net-_Q21-C_ Net-_Q27-B_ 10k
R69 GND Net-_Q26-B_ 22k
Q24 Net-_Q23-E_ Net-_Q24-B_ GND 2N3904
R75 Net-_Q25-C_ Net-_Q29-B_ 10k
Q25 Net-_Q25-C_ Net-_Q25-B_ GND 2N3904
R70 +5V Net-_Q25-C_ 4.7k
R63 +5V Net-_Q23-C_ 4.7k
R67 GND Net-_Q25-B_ 22k
R53 Net-_Q14-C_ Net-_Q23-B_ 10k
R64 Net-_Q23-C_ Net-_Q25-B_ 10k
Q23 Net-_Q23-C_ Net-_Q23-B_ Net-_Q23-E_ 2N3904
R78 +5V Net-_Q29-C_ 4.7k
R81 GND Net-_Q31-B_ 22k
R80 Net-_Q29-C_ Net-_Q31-B_ 10k
R82 +5V /Cin1 4.7k
R77 Net-_Q17-C_ Net-_Q30-B_ 10k
R79 GND Net-_Q30-B_ 22k
Q30 Net-_Q29-C_ Net-_Q30-B_ GND 2N3904
R76 GND Net-_Q29-B_ 22k
Q29 Net-_Q29-C_ Net-_Q29-B_ GND 2N3904
Q31 /Cin1 Net-_Q31-B_ GND 2N3904
Q20 Net-_Q20-C_ Net-_Q20-B_ GND 2N3904
R61 +5V Net-_Q20-C_ 4.7k
Q28 S0 Net-_Q28-B_ GND 2N3904
R73 GND Net-_Q28-B_ 22k
R72 Net-_Q26-C_ Net-_Q28-B_ 10k
R71 +5V Net-_Q26-C_ 4.7k
R74 +5V S0 2.2k
R2 +5V Net-_Q1-B_ 10k
R4 Net-_Q1-C_ Net-_Q3-B_ 10k
R3 +5V Net-_Q2-B_ 10k
R14 GND Net-_Q3-B_ 22k
Q3 Net-_Q3-C_ Net-_Q3-B_ GND 2N3904
R13 GND Net-_Q2-B_ 22k
Q2 Net-_Q1-E_ Net-_Q2-B_ GND 2N3904
Q1 Net-_Q1-C_ Net-_Q1-B_ Net-_Q1-E_ 2N3904
R12 GND Net-_Q1-B_ 22k
V1 +5V GND DC 5
R1 +5V Net-_Q1-C_ 4.7k
R5 +5V Net-_Q3-C_ 4.7k
Q83 ENCA_N2 Net-_Q83-B_ GND 2N3904
Q85 ENCA_N2 Net-_Q85-B_ GND 2N3904
R224 GND Net-_Q85-B_ 22k
R216 GND Net-_Q82-B_ 22k
Q82 ENCA_N2 Net-_Q82-B_ GND 2N3904
R217 Y6 Net-_Q83-B_ 10k
R219 GND Net-_Q83-B_ 22k
R218 +5V ENCA_N2 4.7k
R10 A0 Net-_Q7-B_ 10k
R19 GND Net-_Q7-B_ 22k
Q7 Net-_Q7-C_ Net-_Q7-B_ GND 2N3904
R11 Net-_Q4-C_ Net-_Q6-B_ 10k
R9 +5V Net-_Q5-B_ 10k
Q4 Net-_Q4-C_ Net-_Q4-B_ GND 2N3904
R15 GND Net-_Q4-B_ 22k
R18 +5V Net-_Q6-C_ 4.7k
R16 GND Net-_Q5-B_ 22k
Q5 Net-_Q4-C_ Net-_Q5-B_ GND 2N3904
R7 +5V Net-_Q4-B_ 10k
R17 GND Net-_Q6-B_ 22k
Q6 Net-_Q6-C_ Net-_Q6-B_ GND 2N3904
R8 +5V Net-_Q4-C_ 4.7k
R223 Y5 Net-_Q85-B_ 10k
R215 Y7 Net-_Q82-B_ 10k
R235 GND Net-_Q90-B_ 22k
Q18 Net-_Q18-C_ Net-_Q18-B_ GND 2N3904
R21 +5V Net-_Q7-C_ 4.7k
R225 Y4 Net-_Q86-B_ 10k
R229 GND Net-_Q87-B_ 22k
R226 Y7 Net-_Q87-B_ 10k
Q87 ENCA_N1 Net-_Q87-B_ GND 2N3904
Q90 ENCA_N1 Net-_Q90-B_ GND 2N3904
Q88 ENCA_N1 Net-_Q88-B_ GND 2N3904
R228 Y3 Net-_Q88-B_ 10k
R232 Y2 Net-_Q90-B_ 10k
R230 GND Net-_Q88-B_ 22k
R233 +5V ENCA_N1 4.7k
R231 Y6 Net-_Q89-B_ 10k
Q89 ENCA_N1 Net-_Q89-B_ GND 2N3904
R234 GND Net-_Q89-B_ 22k
R227 GND Net-_Q86-B_ 22k
Q86 ENCA_N2 Net-_Q86-B_ GND 2N3904
R46 Net-_Q14-C_ Net-_Q18-B_ 10k
R49 +5V Net-_Q18-C_ 4.7k
R25 +5V Net-_Q9-C_ 4.7k
R242 GND Net-_Q93-B_ 22k
Q93 ENCA_N0 Net-_Q93-B_ GND 2N3904
R240 Y3 Net-_Q93-B_ 10k
R245 +5V ENCA_N0 4.7k
R239 Y7 Net-_Q92-B_ 10k
R241 GND Net-_Q92-B_ 22k
Q92 ENCA_N0 Net-_Q92-B_ GND 2N3904
R243 Y5 Net-_Q94-B_ 10k
Q94 ENCA_N0 Net-_Q94-B_ GND 2N3904
R246 GND Net-_Q94-B_ 22k
R244 Y1 Net-_Q95-B_ 10k
R247 GND Net-_Q95-B_ 22k
Q95 ENCA_N0 Net-_Q95-B_ GND 2N3904
R99 +5V Net-_Q35-C_ 4.7k
Q35 Net-_Q35-C_ Net-_Q35-B_ Net-_Q35-E_ 2N3904
R103 Net-_Q35-C_ Net-_Q41-B_ 10k
R102 Net-_Q34-C_ Net-_Q40-B_ 10k
R106 GND Net-_Q40-B_ 22k
Q40 Net-_Q40-C_ Net-_Q40-B_ Net-_Q40-E_ 2N3904
Q41 Net-_Q40-E_ Net-_Q41-B_ GND 2N3904
R105 GND Net-_Q41-B_ 22k
R108 +5V Net-_Q40-C_ 4.7k
R111 +5V Net-_Q42-C_ 4.7k
Q42 Net-_Q42-C_ Net-_Q42-B_ GND 2N3904
R110 GND Net-_Q42-B_ 22k
R109 Net-_Q40-C_ Net-_Q42-B_ 10k
Q33 Net-_Q32-C_ Net-_Q33-B_ GND 2N3904
R92 Net-_Q32-C_ Net-_Q34-B_ 10k
R96 GND Net-_Q34-B_ 22k
Q34 Net-_Q34-C_ Net-_Q34-B_ GND 2N3904
R98 +5V Net-_Q34-C_ 4.7k
R88 A1 Net-_Q35-B_ 10k
R89 /B1 Net-_Q36-B_ 10k
R94 GND Net-_Q35-B_ 22k
R107 +5V Net-_Q39-C_ 4.7k
R95 GND Net-_Q38-B_ 22k
Q37 Net-_Q37-C_ Net-_Q37-B_ Net-_Q37-E_ 2N3904
R93 GND Net-_Q36-B_ 22k
Q36 Net-_Q35-E_ Net-_Q36-B_ GND 2N3904
R117 Net-_Q42-C_ Net-_Q46-B_ 10k
R123 GND Net-_Q46-B_ 22k
Q46 Net-_Q46-C_ Net-_Q46-B_ Net-_Q46-E_ 2N3904
R128 +5V Net-_Q46-C_ 4.7k
R114 /Cin1 Net-_Q44-B_ 10k
R113 GND Net-_Q43-B_ 22k
R116 GND Net-_Q44-B_ 22k
Q44 Net-_Q43-C_ Net-_Q44-B_ GND 2N3904
R125 GND Net-_Q45-B_ 22k
Q45 Net-_Q45-C_ Net-_Q45-B_ GND 2N3904
R127 +5V Net-_Q45-C_ 4.7k
R121 Net-_Q43-C_ Net-_Q45-B_ 10k
Q43 Net-_Q43-C_ Net-_Q43-B_ GND 2N3904
R115 +5V Net-_Q43-C_ 4.7k
R112 Net-_Q42-C_ Net-_Q43-B_ 10k
R130 Net-_Q48-C_ Net-_Q50-B_ 10k
Q48 Net-_Q48-C_ Net-_Q48-B_ Net-_Q48-E_ 2N3904
R126 GND Net-_Q48-B_ 22k
R119 Net-_Q42-C_ Net-_Q48-B_ 10k
R136 +5V Net-_Q50-C_ 4.7k
R129 +5V Net-_Q48-C_ 4.7k
R134 GND Net-_Q52-B_ 22k
R120 /Cin1 Net-_Q49-B_ 10k
R124 GND Net-_Q49-B_ 22k
Q49 Net-_Q48-E_ Net-_Q49-B_ GND 2N3904
Q47 Net-_Q46-E_ Net-_Q47-B_ GND 2N3904
R122 GND Net-_Q47-B_ 22k
R118 /Cin1 Net-_Q47-B_ 10k
Q50 Net-_Q50-C_ Net-_Q50-B_ GND 2N3904
R133 GND Net-_Q50-B_ 22k
R145 GND Net-_Q55-B_ 22k
Q55 Net-_Q54-C_ Net-_Q55-B_ GND 2N3904
R143 Net-_Q39-C_ Net-_Q55-B_ 10k
R144 +5V Net-_Q54-C_ 4.7k
Q54 Net-_Q54-C_ Net-_Q54-B_ GND 2N3904
R141 Net-_Q50-C_ Net-_Q54-B_ 10k
R142 GND Net-_Q54-B_ 22k
R146 Net-_Q54-C_ Net-_Q56-B_ 10k
R147 GND Net-_Q56-B_ 22k
Q56 /Cin2 Net-_Q56-B_ GND 2N3904
R148 +5V /Cin2 4.7k
Q52 Net-_Q51-E_ Net-_Q52-B_ GND 2N3904
R135 GND Net-_Q51-B_ 22k
Q51 Net-_Q51-C_ Net-_Q51-B_ Net-_Q51-E_ 2N3904
Q53 S1 Net-_Q53-B_ GND 2N3904
R139 GND Net-_Q53-B_ 22k
R138 Net-_Q51-C_ Net-_Q53-B_ 10k
R131 Net-_Q45-C_ Net-_Q51-B_ 10k
R137 +5V Net-_Q51-C_ 4.7k
R140 +5V S1 2.2k
R132 Net-_Q46-C_ Net-_Q52-B_ 10k
R100 +5V Net-_Q37-C_ 4.7k
R101 Net-_Q37-C_ Net-_Q39-B_ 10k
R97 GND Net-_Q37-B_ 22k
R104 GND Net-_Q39-B_ 22k
Q39 Net-_Q39-C_ Net-_Q39-B_ GND 2N3904
R91 /B1 Net-_Q38-B_ 10k
R90 A1 Net-_Q37-B_ 10k
Q38 Net-_Q37-E_ Net-_Q38-B_ GND 2N3904
Q154 Net-_Q154-C_ Net-_Q154-B_ GND 2N3904
R403 +5V Net-_Q154-C_ 4.7k
R400 GND Net-_Q154-B_ 22k
R416 Net-_Q154-C_ Net-_Q164-B_ 10k
Q164 Net-_Q163-E_ Net-_Q164-B_ GND 2N3904
R420 GND Net-_Q164-B_ 22k
R411 +5V Net-_Q158-C_ 4.7k
R402 GND Net-_Q155-B_ 22k
Q155 Net-_Q155-C_ Net-_Q155-B_ Net-_Q155-E_ 2N3904
Q157 OUT1 Net-_Q157-B_ GND 2N3904
R406 GND Net-_Q157-B_ 22k
R407 +5V OUT1 4.7k
R405 Net-_Q155-C_ Net-_Q157-B_ 10k
R404 +5V Net-_Q155-C_ 4.7k
R401 GND Net-_Q156-B_ 22k
Q156 Net-_Q155-E_ Net-_Q156-B_ GND 2N3904
R442 GND Net-_Q171-B_ 22k
R447 +5V SIG 4.7k
R446 GND Net-_Q172-B_ 22k
Q172 SIG Net-_Q172-B_ GND 2N3904
R440 Net-_Q169-C_ Net-_Q170-B_ 10k
Q170 Net-_Q170-C_ Net-_Q170-B_ Net-_Q170-E_ 2N3904
Q171 Net-_Q170-E_ Net-_Q171-B_ GND 2N3904
R443 GND Net-_Q170-B_ 22k
R441 SUB Net-_Q171-B_ 10k
R444 +5V Net-_Q170-C_ 4.7k
R445 Net-_Q170-C_ Net-_Q172-B_ 10k
Q239 Net-_Q239-C_ Net-_Q239-B_ GND 2N3904
R623 +5V Net-_Q239-C_ 4.7k
R622 GND Net-_Q239-B_ 22k
R621 Net-_Q235-C_ Net-_Q239-B_ 10k
R409 GND Net-_Q158-B_ 22k
Q158 Net-_Q158-C_ Net-_Q158-B_ GND 2N3904
R408 Net-_Q196-C_ Net-_Q158-B_ 10k
R419 GND Net-_Q161-B_ 22k
Q161 Net-_Q161-C_ Net-_Q161-B_ Net-_Q161-E_ 2N3904
R421 GND Net-_Q160-B_ 22k
R417 Net-_Q158-C_ Net-_Q160-B_ 10k
Q160 Net-_Q160-C_ Net-_Q160-B_ GND 2N3904
R423 +5V Net-_Q160-C_ 4.7k
R413 Net-_Q196-C_ Net-_Q161-B_ 10k
Q159 Net-_Q158-C_ Net-_Q159-B_ GND 2N3904
R410 Net-_Q154-C_ Net-_Q159-B_ 10k
R412 GND Net-_Q159-B_ 22k
R424 +5V Net-_Q161-C_ 4.7k
R428 Net-_Q161-C_ Net-_Q167-B_ 10k
R427 Net-_Q160-C_ Net-_Q166-B_ 10k
R426 Net-_Q163-C_ Net-_Q165-B_ 10k
R429 GND Net-_Q165-B_ 22k
Q163 Net-_Q163-C_ Net-_Q163-B_ Net-_Q163-E_ 2N3904
R422 GND Net-_Q163-B_ 22k
R425 +5V Net-_Q163-C_ 4.7k
R415 Net-_Q196-C_ Net-_Q163-B_ 10k
R414 Net-_Q154-C_ Net-_Q162-B_ 10k
R418 GND Net-_Q162-B_ 22k
Q162 Net-_Q161-E_ Net-_Q162-B_ GND 2N3904
R432 +5V Net-_Q165-C_ 4.7k
Q165 Net-_Q165-C_ Net-_Q165-B_ GND 2N3904
Q200 Net-_Q200-C_ Net-_Q200-B_ Net-_Q200-E_ 2N3904
R522 GND Net-_Q200-B_ 22k
R523 GND Net-_Q203-B_ 22k
Q203 Net-_Q202-E_ Net-_Q203-B_ GND 2N3904
R519 Net-_Q165-C_ Net-_Q203-B_ 10k
R518 S3 Net-_Q202-B_ 10k
Q202 Net-_Q202-C_ Net-_Q202-B_ Net-_Q202-E_ 2N3904
R525 GND Net-_Q202-B_ 22k
Q204 /OUT4 Net-_Q204-B_ GND 2N3904
R529 Net-_Q202-C_ Net-_Q204-B_ 10k
R528 +5V Net-_Q202-C_ 4.7k
R532 GND Net-_Q204-B_ 22k
R521 GND Net-_Q201-B_ 22k
Q201 Net-_Q200-E_ Net-_Q201-B_ GND 2N3904
R517 Net-_Q165-C_ Net-_Q201-B_ 10k
R516 S3 Net-_Q200-B_ 10k
R534 GND Net-_Q205-B_ 22k
Q205 Net-_Q205-C_ Net-_Q205-B_ Net-_Q205-E_ 2N3904
R527 +5V Net-_Q200-C_ 4.7k
R531 Net-_Q200-C_ Net-_Q206-B_ 10k
R539 +5V OUT3 4.7k
R536 +5V Net-_Q205-C_ 4.7k
R530 Net-_Q199-C_ Net-_Q205-B_ 10k
R538 GND Net-_Q207-B_ 22k
R537 Net-_Q205-C_ Net-_Q207-B_ 10k
Q207 OUT3 Net-_Q207-B_ GND 2N3904
R533 GND Net-_Q206-B_ 22k
Q206 Net-_Q205-E_ Net-_Q206-B_ GND 2N3904
R535 +5V /OUT4 4.7k
R524 GND Net-_Q199-B_ 22k
Q198 Net-_Q197-C_ Net-_Q198-B_ GND 2N3904
R515 GND Net-_Q198-B_ 22k
R513 Net-_Q165-C_ Net-_Q198-B_ 10k
R431 GND Net-_Q166-B_ 22k
Q167 Net-_Q166-E_ Net-_Q167-B_ GND 2N3904
R430 GND Net-_Q167-B_ 22k
R433 +5V Net-_Q166-C_ 4.7k
R436 +5V OUT2 4.7k
Q166 Net-_Q166-C_ Net-_Q166-B_ Net-_Q166-E_ 2N3904
R435 GND Net-_Q168-B_ 22k
Q168 OUT2 Net-_Q168-B_ GND 2N3904
R434 Net-_Q166-C_ Net-_Q168-B_ 10k
R645 GND Net-_Q248-B_ 22k
Q248 Net-_Q248-C_ Net-_Q248-B_ GND 2N3904
R661 GND Net-_Q254-B_ 22k
R697 GND Net-_Q268-B_ 22k
Q268 Net-_Q268-C_ Net-_Q268-B_ GND 2N3904
R724 +5V Net-_Q277-C_ 4.7k
Q275 Net-_Q275-C_ Net-_Q275-B_ Net-_Q275-E_ 2N3904
R723 +5V Net-_Q275-C_ 4.7k
Q276 Net-_Q275-E_ Net-_Q276-B_ GND 2N3904
R807 +5V /F_OUT0 4.7k
R896 OUT_B0 Net-_Q348-B_ 10k
R897 GND Net-_Q348-B_ 22k
R898 +5V Net-_Q348-C_ 4.7k
Q348 Net-_Q348-C_ Net-_Q348-B_ GND 2N3904
R958 +5V Net-_Q368-C_ 4.7k
R1094 +5V /F_OUT8 4.7k
R1056 +5V Net-_Q388-C_ 4.7k
R716 Net-_Q275-C_ Net-_Q277-B_ 10k
R717 Net-_Q272-C_ Net-_Q278-B_ 10k
R718 +5V Net-_Q274-C_ 4.7k
R722 GND Net-_Q277-B_ 22k
Q278 Net-_Q277-E_ Net-_Q278-B_ GND 2N3904
R720 GND Net-_Q278-B_ 22k
Q277 Net-_Q277-C_ Net-_Q277-B_ Net-_Q277-E_ 2N3904
Q274 Net-_Q274-C_ Net-_Q274-B_ GND 2N3904
R712 Net-_Q268-C_ Net-_Q274-B_ 10k
R713 GND Net-_Q274-B_ 22k
R714 Net-_Q270-C_ Net-_Q275-B_ 10k
R719 GND Net-_Q276-B_ 22k
R721 GND Net-_Q275-B_ 22k
R715 Net-_Q277-C_ Net-_Q276-B_ 10k
R692 GND Net-_Q264-B_ 22k
R686 Net-_Q260-C_ Net-_Q264-B_ 10k
R694 +5V OUT_B2 2.2k
Q264 OUT_B2 Net-_Q264-B_ Net-_Q264-E_ 2N3904
R684 +5V Net-_Q260-C_ 4.7k
R677 Net-_Q254-C_ Net-_Q261-B_ 10k
Q260 Net-_Q260-C_ Net-_Q260-B_ Net-_Q260-E_ 2N3904
R676 Net-_Q255-C_ Net-_Q260-B_ 10k
R682 GND Net-_Q260-B_ 22k
R680 GND Net-_Q261-B_ 22k
Q261 Net-_Q260-E_ Net-_Q261-B_ GND 2N3904
R700 GND Net-_Q269-B_ 22k
R699 +5V Net-_Q268-C_ 2.2k
R701 +5V Net-_Q269-C_ 4.7k
Q269 Net-_Q269-C_ Net-_Q269-B_ GND 2N3904
R698 REG_D1 Net-_Q269-B_ 10k
R696 MEMCLK Net-_Q268-B_ 10k
R711 +5V Net-_Q272-C_ 4.7k
R710 +5V Net-_Q270-C_ 4.7k
R702 REG_D1 Net-_Q270-B_ 10k
Q270 Net-_Q270-C_ Net-_Q270-B_ Net-_Q270-E_ 2N3904
R708 GND Net-_Q270-B_ 22k
R703 Net-_Q268-C_ Net-_Q271-B_ 10k
Q273 Net-_Q272-E_ Net-_Q273-B_ GND 2N3904
Q272 Net-_Q272-C_ Net-_Q272-B_ Net-_Q272-E_ 2N3904
R709 GND Net-_Q272-B_ 22k
R704 Net-_Q268-C_ Net-_Q272-B_ 10k
R705 Net-_Q269-C_ Net-_Q273-B_ 10k
R707 GND Net-_Q273-B_ 22k
R706 GND Net-_Q271-B_ 22k
Q271 Net-_Q270-E_ Net-_Q271-B_ GND 2N3904
Q262 Net-_Q262-C_ Net-_Q262-B_ Net-_Q262-E_ 2N3904
R673 Net-_Q255-C_ Net-_Q259-B_ 10k
R674 GND Net-_Q259-B_ 22k
R675 +5V Net-_Q259-C_ 4.7k
Q259 Net-_Q259-C_ Net-_Q259-B_ GND 2N3904
R683 GND Net-_Q262-B_ 22k
R679 Net-_Q259-C_ Net-_Q263-B_ 10k
R678 Net-_Q254-C_ Net-_Q262-B_ 10k
R685 +5V Net-_Q262-C_ 4.7k
Q263 Net-_Q262-E_ Net-_Q263-B_ GND 2N3904
R681 GND Net-_Q263-B_ 22k
R688 OUT_B2 Net-_Q266-B_ 10k
Q267 Net-_Q266-E_ Net-_Q267-B_ GND 2N3904
R695 +5V Net-_Q266-C_ 4.7k
Q266 Net-_Q266-C_ Net-_Q266-B_ Net-_Q266-E_ 2N3904
R693 GND Net-_Q266-B_ 22k
R690 GND Net-_Q265-B_ 22k
Q265 Net-_Q264-E_ Net-_Q265-B_ GND 2N3904
R691 GND Net-_Q267-B_ 22k
R689 Net-_Q262-C_ Net-_Q267-B_ 10k
R687 Net-_Q266-C_ Net-_Q265-B_ 10k
R3054 OP0N Net-_Q2411-B_ 10k
Q2444 Net-_Q2443-E_ Net-_Q2444-B_ GND 2N3904
R3141 Net-_Q2444-B_ GND 22k
R3139 Net-_Q2443-B_ GND 22k
R3137 +5V OUT_B4.QN 4.7k
Q2443 OUT_B4.QN Net-_Q2443-B_ Net-_Q2443-E_ 2N3904
R3055 Net-_Q2411-B_ GND 22k
Q2411 Net-_Q2410-E_ Net-_Q2411-B_ GND 2N3904
R3053 Net-_Q2410-B_ GND 22k
R3138 OUT_B4 Net-_Q2443-B_ 10k
R3140 OUT_B4.S2 Net-_Q2444-B_ 10k
R3143 MEMCLK2 Net-_Q2445-B_ 10k
R3142 +5V OUT_B5.CLKN 2.2k
R3144 Net-_Q2445-B_ GND 22k
Q2445 OUT_B5.CLKN Net-_Q2445-B_ GND 2N3904
R3147 Net-_Q2446-B_ GND 22k
Q2446 OUT_B5.CLKB Net-_Q2446-B_ GND 2N3904
R3146 OUT_B5.CLKN Net-_Q2446-B_ 10k
R3145 +5V OUT_B5.CLKB 4.7k
R3148 +5V OUT_B5.DN 4.7k
Q2416 RDS_N Net-_Q2416-B_ Net-_Q2416-E_ 2N3904
R3068 Net-_Q2416-B_ GND 22k
R3067 OP1NA Net-_Q2416-B_ 10k
R3066 +5V RDS_N 4.7k
R3069 SIGB2 Net-_Q2417-B_ 10k
R3070 Net-_Q2417-B_ GND 22k
Q2417 Net-_Q2416-E_ Net-_Q2417-B_ GND 2N3904
R3150 Net-_Q2447-B_ GND 22k
Q2447 OUT_B5.DN Net-_Q2447-B_ GND 2N3904
R3149 D5 Net-_Q2447-B_ 10k
R3049 +5V RD_A3 4.7k
R3050 OP1NA Net-_Q2409-B_ 10k
R3052 OUT3 Net-_Q2410-B_ 10k
R3051 Net-_Q2409-B_ GND 22k
Q2409 RD_A3 Net-_Q2409-B_ Net-_Q2409-E_ 2N3904
Q2410 Net-_Q2409-E_ Net-_Q2410-B_ Net-_Q2410-E_ 2N3904
R2997 P5.QN Net-_Q2388-B_ 10k
R2995 P5.S1 Net-_Q2387-B_ 10k
R3060 Net-_Q2413-B_ GND 22k
Q2413 Net-_Q2412-E_ Net-_Q2413-B_ GND 2N3904
Q2412 RD_M3 Net-_Q2412-B_ Net-_Q2412-E_ 2N3904
R3058 Net-_Q2412-B_ GND 22k
R3057 OP1BA Net-_Q2412-B_ 10k
R3059 P3 Net-_Q2413-B_ 10k
R3064 RD_M3 Net-_Q2415-B_ 10k
R3063 Net-_Q2414-B_ GND 22k
R3062 RD_A3 Net-_Q2414-B_ 10k
Q2414 REG_D3 Net-_Q2414-B_ Net-_Q2414-E_ 2N3904
Q2415 Net-_Q2414-E_ Net-_Q2415-B_ GND 2N3904
R3065 Net-_Q2415-B_ GND 22k
R3056 +5V RD_M3 4.7k
R2998 Net-_Q2388-B_ GND 22k
Q2388 Net-_Q2387-E_ Net-_Q2388-B_ GND 2N3904
Q2387 P5 Net-_Q2387-B_ Net-_Q2387-E_ 2N3904
R2996 Net-_Q2387-B_ GND 22k
R3002 P5.S2 Net-_Q2390-B_ 10k
R3001 Net-_Q2389-B_ GND 22k
Q2390 Net-_Q2389-E_ Net-_Q2390-B_ GND 2N3904
Q2389 P5.QN Net-_Q2389-B_ Net-_Q2389-E_ 2N3904
R3000 P5 Net-_Q2389-B_ 10k
R3061 +5V REG_D3 4.7k
R3003 Net-_Q2390-B_ GND 22k
R2567 +5V NX4 4.7k
R2568 NX4.t0 Net-_Q2219-B_ 10k
R2570 NX4.t1 Net-_Q2220-B_ 10k
Q2219 NX4 Net-_Q2219-B_ Net-_Q2219-E_ 2N3904
R2569 Net-_Q2219-B_ GND 22k
Q2220 Net-_Q2219-E_ Net-_Q2220-B_ Net-_Q2220-E_ 2N3904
R2571 Net-_Q2220-B_ GND 22k
R2683 +5V NX0 4.7k
R2572 NX4.t2 Net-_Q2221-B_ 10k
Q2221 Net-_Q2220-E_ Net-_Q2221-B_ Net-_Q2221-E_ 2N3904
R2573 Net-_Q2221-B_ GND 22k
R2574 NX4.t3 Net-_Q2222-B_ 10k
Q2222 Net-_Q2221-E_ Net-_Q2222-B_ GND 2N3904
R2575 Net-_Q2222-B_ GND 22k
R2684 NX0.t0 Net-_Q2267-B_ 10k
R2686 NX0.t1 Net-_Q2268-B_ 10k
R2685 Net-_Q2267-B_ GND 22k
Q2267 NX0 Net-_Q2267-B_ Net-_Q2267-E_ 2N3904
Q2268 Net-_Q2267-E_ Net-_Q2268-B_ Net-_Q2268-E_ 2N3904
R2688 NX0.t2 Net-_Q2269-B_ 10k
R2689 Net-_Q2269-B_ GND 22k
Q2269 Net-_Q2268-E_ Net-_Q2269-B_ Net-_Q2269-E_ 2N3904
R2687 Net-_Q2268-B_ GND 22k
R2576 +5V NX3.t0 4.7k
R2578 Net-_Q2223-B_ GND 22k
Q2223 NX3.t0 Net-_Q2223-B_ Net-_Q2223-E_ 2N3904
R2582 TDQ Net-_Q2225-B_ 10k
R2584 S0 Net-_Q2226-B_ 10k
R2577 TMB Net-_Q2223-B_ 10k
R2579 S1 Net-_Q2224-B_ 10k
Q2224 Net-_Q2223-E_ Net-_Q2224-B_ GND 2N3904
R2580 Net-_Q2224-B_ GND 22k
R2581 +5V NX3.t1 4.7k
R2583 Net-_Q2225-B_ GND 22k
Q2225 NX3.t1 Net-_Q2225-B_ Net-_Q2225-E_ 2N3904
R2587 TDNQ Net-_Q2227-B_ 10k
R2589 P2 Net-_Q2228-B_ 10k
R2588 Net-_Q2227-B_ GND 22k
Q2227 NX3.t2 Net-_Q2227-B_ Net-_Q2227-E_ 2N3904
R2585 Net-_Q2226-B_ GND 22k
Q2226 Net-_Q2225-E_ Net-_Q2226-B_ GND 2N3904
R2586 +5V NX3.t2 4.7k
R2590 Net-_Q2228-B_ GND 22k
Q2228 Net-_Q2227-E_ Net-_Q2228-B_ GND 2N3904
R2557 +5V NX4.t2 4.7k
R2559 Net-_Q2215-B_ GND 22k
Q2215 NX4.t2 Net-_Q2215-B_ Net-_Q2215-E_ 2N3904
Q2218 Net-_Q2217-E_ Net-_Q2218-B_ GND 2N3904
R2566 Net-_Q2218-B_ GND 22k
R2561 Net-_Q2216-B_ GND 22k
Q2216 Net-_Q2215-E_ Net-_Q2216-B_ GND 2N3904
R2562 +5V NX4.t3 4.7k
R2563 IDLE Net-_Q2217-B_ 10k
Q2217 NX4.t3 Net-_Q2217-B_ Net-_Q2217-E_ 2N3904
R2565 P4 Net-_Q2218-B_ 10k
R2564 Net-_Q2217-B_ GND 22k
R2678 +5V NX0.t3 4.7k
Q2265 NX0.t3 Net-_Q2265-B_ Net-_Q2265-E_ 2N3904
R2680 Net-_Q2265-B_ GND 22k
R2682 Net-_Q2266-B_ GND 22k
Q2266 Net-_Q2265-E_ Net-_Q2266-B_ GND 2N3904
R2679 LB Net-_Q2265-B_ 10k
R2681 A0 Net-_Q2266-B_ 10k
R2668 +5V NX0.t1 4.7k
R2669 TDB Net-_Q2261-B_ 10k
R2671 QD Net-_Q2262-B_ 10k
R2672 Net-_Q2262-B_ GND 22k
Q2261 NX0.t1 Net-_Q2261-B_ Net-_Q2261-E_ 2N3904
R2670 Net-_Q2261-B_ GND 22k
Q2262 Net-_Q2261-E_ Net-_Q2262-B_ GND 2N3904
R2673 +5V NX0.t2 4.7k
R2674 IDLE Net-_Q2263-B_ 10k
R2676 P0 Net-_Q2264-B_ 10k
R2677 Net-_Q2264-B_ GND 22k
Q2264 Net-_Q2263-E_ Net-_Q2264-B_ GND 2N3904
R2675 Net-_Q2263-B_ GND 22k
Q2263 NX0.t2 Net-_Q2263-B_ Net-_Q2263-E_ 2N3904
R2552 +5V NX4.t1 4.7k
R2554 Net-_Q2213-B_ GND 22k
Q2213 NX4.t1 Net-_Q2213-B_ Net-_Q2213-E_ 2N3904
R2558 TDNQ Net-_Q2215-B_ 10k
R2560 P3 Net-_Q2216-B_ 10k
R2553 TDQ Net-_Q2213-B_ 10k
R2555 S1 Net-_Q2214-B_ 10k
Q2214 Net-_Q2213-E_ Net-_Q2214-B_ GND 2N3904
R2556 Net-_Q2214-B_ GND 22k
Q2349 P3.QN Net-_Q2349-B_ Net-_Q2349-E_ 2N3904
R2897 Net-_Q2349-B_ GND 22k
R2896 P3 Net-_Q2349-B_ 10k
R2898 P3.S2 Net-_Q2350-B_ 10k
Q2350 Net-_Q2349-E_ Net-_Q2350-B_ GND 2N3904
R2899 Net-_Q2350-B_ GND 22k
Q2382 P5.MQI Net-_Q2382-B_ GND 2N3904
R2981 +5V P5.MQI 4.7k
R2983 Net-_Q2382-B_ GND 22k
R2982 P5.MQ Net-_Q2382-B_ 10k
R2990 P5.CLKB Net-_Q2385-B_ 10k
R2991 Net-_Q2385-B_ GND 22k
Q2385 P5.S2 Net-_Q2385-B_ Net-_Q2385-E_ 2N3904
R2984 +5V P5.S1 4.7k
Q2383 P5.S1 Net-_Q2383-B_ Net-_Q2383-E_ 2N3904
R2985 P5.MQ Net-_Q2383-B_ 10k
Q2384 Net-_Q2383-E_ Net-_Q2384-B_ GND 2N3904
R2992 P5.MQI Net-_Q2386-B_ 10k
R2993 Net-_Q2386-B_ GND 22k
Q2386 Net-_Q2385-E_ Net-_Q2386-B_ GND 2N3904
R2988 Net-_Q2384-B_ GND 22k
R2986 Net-_Q2383-B_ GND 22k
R2987 P5.CLKB Net-_Q2384-B_ 10k
R2716 +5V P0.MQN 4.7k
R2717 P0.MQ Net-_Q2280-B_ 10k
R2719 P0.M2 Net-_Q2281-B_ 10k
Q2281 Net-_Q2280-E_ Net-_Q2281-B_ GND 2N3904
Q2280 P0.MQN Net-_Q2280-B_ Net-_Q2280-E_ 2N3904
R2718 Net-_Q2280-B_ GND 22k
R2720 Net-_Q2281-B_ GND 22k
R2890 +5V P3 2.2k
R2802 +5V P2.DN 4.7k
Q2313 P2.DN Net-_Q2313-B_ GND 2N3904
R2804 Net-_Q2313-B_ GND 22k
R2803 NX2 Net-_Q2313-B_ 10k
R2976 +5V P5.MQN 4.7k
R2977 P5.MQ Net-_Q2380-B_ 10k
R2979 P5.M2 Net-_Q2381-B_ 10k
R2978 Net-_Q2380-B_ GND 22k
Q2380 P5.MQN Net-_Q2380-B_ Net-_Q2380-E_ 2N3904
R2980 Net-_Q2381-B_ GND 22k
Q2381 Net-_Q2380-E_ Net-_Q2381-B_ GND 2N3904
R2891 P3.S1 Net-_Q2347-B_ 10k
R2893 P3.QN Net-_Q2348-B_ 10k
R2892 Net-_Q2347-B_ GND 22k
Q2347 P3 Net-_Q2347-B_ Net-_Q2347-E_ 2N3904
R2894 Net-_Q2348-B_ GND 22k
Q2348 Net-_Q2347-E_ Net-_Q2348-B_ GND 2N3904
R2691 Net-_Q2270-B_ GND 22k
Q2270 Net-_Q2269-E_ Net-_Q2270-B_ GND 2N3904
R2690 NX0.t3 Net-_Q2270-B_ 10k
R2734 +5V P0 2.2k
R2827 Net-_Q2322-B_ GND 22k
R2826 P2.MQ Net-_Q2322-B_ 10k
R2740 P0 Net-_Q2289-B_ 10k
R2742 P0.S2 Net-_Q2290-B_ 10k
Q2322 P2.MQI Net-_Q2322-B_ GND 2N3904
R2825 +5V P2.MQI 4.7k
R2743 Net-_Q2290-B_ GND 22k
Q2290 Net-_Q2289-E_ Net-_Q2290-B_ GND 2N3904
R2741 Net-_Q2289-B_ GND 22k
R2739 +5V P0.QN 4.7k
Q2289 P0.QN Net-_Q2289-B_ Net-_Q2289-E_ 2N3904
R2823 P2.M2 Net-_Q2321-B_ 10k
R2821 P2.MQ Net-_Q2320-B_ 10k
R2822 Net-_Q2320-B_ GND 22k
Q2320 P2.MQN Net-_Q2320-B_ Net-_Q2320-E_ 2N3904
R2735 P0.S1 Net-_Q2287-B_ 10k
R2737 P0.QN Net-_Q2288-B_ 10k
R2820 +5V P2.MQN 4.7k
R2736 Net-_Q2287-B_ GND 22k
Q2287 P0 Net-_Q2287-B_ Net-_Q2287-E_ 2N3904
R2738 Net-_Q2288-B_ GND 22k
Q2288 Net-_Q2287-E_ Net-_Q2288-B_ GND 2N3904
R2913 Net-_Q2355-B_ GND 22k
R2910 NX4 Net-_Q2354-B_ 10k
R2912 P4.CLKN Net-_Q2355-B_ 10k
Q2354 P4.M1 Net-_Q2354-B_ Net-_Q2354-E_ 2N3904
R2911 Net-_Q2354-B_ GND 22k
Q2355 Net-_Q2354-E_ Net-_Q2355-B_ GND 2N3904
R2994 +5V P5 2.2k
R2989 +5V P5.S2 4.7k
R2999 +5V P5.QN 4.7k
Q2291 P1.CLKN Net-_Q2291-B_ GND 2N3904
R2746 Net-_Q2291-B_ GND 22k
R2829 P2.MQ Net-_Q2323-B_ 10k
R2831 P2.CLKB Net-_Q2324-B_ 10k
R2828 +5V P2.S1 4.7k
Q2323 P2.S1 Net-_Q2323-B_ Net-_Q2323-E_ 2N3904
R2830 Net-_Q2323-B_ GND 22k
R2745 CK2 Net-_Q2291-B_ 10k
R2744 +5V P1.CLKN 2.2k
R2824 Net-_Q2321-B_ GND 22k
Q2321 Net-_Q2320-E_ Net-_Q2321-B_ GND 2N3904
R2909 +5V P4.M1 4.7k
R2906 +5V P4.DN 4.7k
R2914 +5V P4.M2 4.7k
Q2324 Net-_Q2323-E_ Net-_Q2324-B_ GND 2N3904
R2832 Net-_Q2324-B_ GND 22k
Q2357 Net-_Q2356-E_ Net-_Q2357-B_ GND 2N3904
R2918 Net-_Q2357-B_ GND 22k
Q2356 P4.M2 Net-_Q2356-B_ Net-_Q2356-E_ 2N3904
R2915 P4.CLKN Net-_Q2356-B_ 10k
R2917 P4.DN Net-_Q2357-B_ 10k
R2916 Net-_Q2356-B_ GND 22k
R2907 NX4 Net-_Q2353-B_ 10k
R2908 Net-_Q2353-B_ GND 22k
Q2353 P4.DN Net-_Q2353-B_ GND 2N3904
R2901 CK2 Net-_Q2351-B_ 10k
R2814 Net-_Q2317-B_ GND 22k
R2895 +5V P3.QN 4.7k
R2900 +5V P4.CLKN 2.2k
R2902 Net-_Q2351-B_ GND 22k
Q2351 P4.CLKN Net-_Q2351-B_ GND 2N3904
R2815 +5V P2.MQ 4.7k
R2819 Net-_Q2319-B_ GND 22k
R2816 P2.M1 Net-_Q2318-B_ 10k
R2818 P2.MQN Net-_Q2319-B_ 10k
Q2318 P2.MQ Net-_Q2318-B_ Net-_Q2318-E_ 2N3904
R2817 Net-_Q2318-B_ GND 22k
Q2319 Net-_Q2318-E_ Net-_Q2319-B_ GND 2N3904
Q2352 P4.CLKB Net-_Q2352-B_ GND 2N3904
R2903 +5V P4.CLKB 4.7k
R2905 Net-_Q2352-B_ GND 22k
R2904 P4.CLKN Net-_Q2352-B_ 10k
R2810 +5V P2.M2 4.7k
R2813 P2.DN Net-_Q2317-B_ 10k
R2811 P2.CLKN Net-_Q2316-B_ 10k
Q2317 Net-_Q2316-E_ Net-_Q2317-B_ GND 2N3904
Q2316 P2.M2 Net-_Q2316-B_ Net-_Q2316-E_ 2N3904
R2812 Net-_Q2316-B_ GND 22k
R2805 +5V P2.M1 4.7k
R2806 NX2 Net-_Q2314-B_ 10k
R2808 P2.CLKN Net-_Q2315-B_ 10k
Q2314 P2.M1 Net-_Q2314-B_ Net-_Q2314-E_ 2N3904
R2807 Net-_Q2314-B_ GND 22k
Q2315 Net-_Q2314-E_ Net-_Q2315-B_ GND 2N3904
R2809 Net-_Q2315-B_ GND 22k
R2725 P0.MQ Net-_Q2283-B_ 10k
R2727 P0.CLKB Net-_Q2284-B_ 10k
R2721 +5V P0.MQI 4.7k
Q2282 P0.MQI Net-_Q2282-B_ GND 2N3904
R2723 Net-_Q2282-B_ GND 22k
R2722 P0.MQ Net-_Q2282-B_ 10k
R2728 Net-_Q2284-B_ GND 22k
Q2284 Net-_Q2283-E_ Net-_Q2284-B_ GND 2N3904
R2724 +5V P0.S1 4.7k
Q2283 P0.S1 Net-_Q2283-B_ Net-_Q2283-E_ 2N3904
R2726 Net-_Q2283-B_ GND 22k
R2730 P0.CLKB Net-_Q2285-B_ 10k
R2732 P0.MQI Net-_Q2286-B_ 10k
R2731 Net-_Q2285-B_ GND 22k
R2733 Net-_Q2286-B_ GND 22k
Q2286 Net-_Q2285-E_ Net-_Q2286-B_ GND 2N3904
Q2285 P0.S2 Net-_Q2285-B_ Net-_Q2285-E_ 2N3904
R2729 +5V P0.S2 4.7k
R3072 RDS_N Net-_Q2418-B_ 10k
Q2421 D4 Net-_Q2421-B_ GND 2N3904
R3081 Net-_Q2421-B_ GND 22k
R3161 +5V OUT_B5.MQ 4.7k
R3162 OUT_B5.M1 Net-_Q2452-B_ 10k
R3164 OUT_B5.MQN Net-_Q2453-B_ 10k
R3165 Net-_Q2453-B_ GND 22k
Q2453 Net-_Q2452-E_ Net-_Q2453-B_ GND 2N3904
Q2452 OUT_B5.MQ Net-_Q2452-B_ Net-_Q2452-E_ 2N3904
R3163 Net-_Q2452-B_ GND 22k
R3079 +5V D4 4.7k
R3080 D4_N Net-_Q2421-B_ 10k
R3156 +5V OUT_B5.M2 4.7k
R3158 Net-_Q2450-B_ GND 22k
Q2450 OUT_B5.M2 Net-_Q2450-B_ Net-_Q2450-E_ 2N3904
R3157 OUT_B5.CLKN Net-_Q2450-B_ 10k
R3159 OUT_B5.DN Net-_Q2451-B_ 10k
Q2451 Net-_Q2450-E_ Net-_Q2451-B_ GND 2N3904
R3160 Net-_Q2451-B_ GND 22k
R3155 Net-_Q2449-B_ GND 22k
Q2449 Net-_Q2448-E_ Net-_Q2449-B_ GND 2N3904
R3151 +5V OUT_B5.M1 4.7k
R3152 D5 Net-_Q2448-B_ 10k
R3154 OUT_B5.CLKN Net-_Q2449-B_ 10k
Q2448 OUT_B5.M1 Net-_Q2448-B_ Net-_Q2448-E_ 2N3904
R3153 Net-_Q2448-B_ GND 22k
Q2419 D4_N Net-_Q2419-B_ Net-_Q2419-E_ 2N3904
R3076 Net-_Q2419-B_ GND 22k
Q2420 Net-_Q2419-E_ Net-_Q2420-B_ GND 2N3904
R3078 Net-_Q2420-B_ GND 22k
R3075 OP1BB Net-_Q2419-B_ 10k
R3077 P4 Net-_Q2420-B_ 10k
R3074 +5V D4_N 4.7k
R3071 +5V REG_DS 4.7k
Q2418 REG_DS Net-_Q2418-B_ GND 2N3904
R3073 Net-_Q2418-B_ GND 22k
R2605 +5V NX2.t0 4.7k
R2607 Net-_Q2235-B_ GND 22k
Q2235 NX2.t0 Net-_Q2235-B_ Net-_Q2235-E_ 2N3904
R2611 TDB Net-_Q2237-B_ 10k
R2613 P1 Net-_Q2238-B_ 10k
Q2237 NX2.t1 Net-_Q2237-B_ Net-_Q2237-E_ 2N3904
R2612 Net-_Q2237-B_ GND 22k
R2609 Net-_Q2236-B_ GND 22k
Q2236 Net-_Q2235-E_ Net-_Q2236-B_ GND 2N3904
R2610 +5V NX2.t1 4.7k
Q2238 Net-_Q2237-E_ Net-_Q2238-B_ GND 2N3904
R2614 Net-_Q2238-B_ GND 22k
R2615 +5V NX2.t2 4.7k
R2619 Net-_Q2240-B_ GND 22k
Q2240 Net-_Q2239-E_ Net-_Q2240-B_ GND 2N3904
R2621 LB Net-_Q2241-B_ 10k
R2623 A2 Net-_Q2242-B_ 10k
R2617 Net-_Q2239-B_ GND 22k
Q2239 NX2.t2 Net-_Q2239-B_ Net-_Q2239-E_ 2N3904
R2616 IDLE Net-_Q2239-B_ 10k
R2618 P2 Net-_Q2240-B_ 10k
R2624 Net-_Q2242-B_ GND 22k
R2622 Net-_Q2241-B_ GND 22k
Q2242 Net-_Q2241-E_ Net-_Q2242-B_ GND 2N3904
Q2241 NX2.t3 Net-_Q2241-B_ Net-_Q2241-E_ 2N3904
R2628 NX2.t1 Net-_Q2244-B_ 10k
R2626 NX2.t0 Net-_Q2243-B_ 10k
R2620 +5V NX2.t3 4.7k
R2625 +5V NX2 4.7k
R2627 Net-_Q2243-B_ GND 22k
Q2243 NX2 Net-_Q2243-B_ Net-_Q2243-E_ 2N3904
Q2244 Net-_Q2243-E_ Net-_Q2244-B_ Net-_Q2244-E_ 2N3904
Q2245 Net-_Q2244-E_ Net-_Q2245-B_ Net-_Q2245-E_ 2N3904
R2629 Net-_Q2244-B_ GND 22k
R2630 NX2.t2 Net-_Q2245-B_ 10k
R2631 Net-_Q2245-B_ GND 22k
R2632 NX2.t3 Net-_Q2246-B_ 10k
Q2246 Net-_Q2245-E_ Net-_Q2246-B_ GND 2N3904
R2633 Net-_Q2246-B_ GND 22k
Q2328 Net-_Q2327-E_ Net-_Q2328-B_ GND 2N3904
R2842 Net-_Q2328-B_ GND 22k
R2928 Net-_Q2361-B_ GND 22k
Q2361 Net-_Q2360-E_ Net-_Q2361-B_ GND 2N3904
R2924 +5V P4.MQN 4.7k
R2925 P4.MQ Net-_Q2360-B_ 10k
R2927 P4.M2 Net-_Q2361-B_ 10k
Q2360 P4.MQN Net-_Q2360-B_ Net-_Q2360-E_ 2N3904
R2926 Net-_Q2360-B_ GND 22k
R2923 Net-_Q2359-B_ GND 22k
Q2359 Net-_Q2358-E_ Net-_Q2359-B_ GND 2N3904
R2835 Net-_Q2325-B_ GND 22k
R2836 P2.MQI Net-_Q2326-B_ 10k
R2837 Net-_Q2326-B_ GND 22k
Q2326 Net-_Q2325-E_ Net-_Q2326-B_ GND 2N3904
Q2358 P4.MQ Net-_Q2358-B_ Net-_Q2358-E_ 2N3904
R2921 Net-_Q2358-B_ GND 22k
R2919 +5V P4.MQ 4.7k
R2920 P4.M1 Net-_Q2358-B_ 10k
R2922 P4.MQN Net-_Q2359-B_ 10k
R2596 +5V NX3 4.7k
R2598 Net-_Q2231-B_ GND 22k
Q2232 Net-_Q2231-E_ Net-_Q2232-B_ Net-_Q2232-E_ 2N3904
Q2231 NX3 Net-_Q2231-B_ Net-_Q2231-E_ 2N3904
R2606 TMB Net-_Q2235-B_ 10k
R2608 S0 Net-_Q2236-B_ 10k
R2600 Net-_Q2232-B_ GND 22k
Q2233 Net-_Q2232-E_ Net-_Q2233-B_ Net-_Q2233-E_ 2N3904
R2604 Net-_Q2234-B_ GND 22k
Q2234 Net-_Q2233-E_ Net-_Q2234-B_ GND 2N3904
R2602 Net-_Q2233-B_ GND 22k
R2603 NX3.t3 Net-_Q2234-B_ 10k
Q2292 P1.CLKB Net-_Q2292-B_ GND 2N3904
R2749 Net-_Q2292-B_ GND 22k
R2747 +5V P1.CLKB 4.7k
R2748 P1.CLKN Net-_Q2292-B_ 10k
R2833 +5V P2.S2 4.7k
Q2325 P2.S2 Net-_Q2325-B_ Net-_Q2325-E_ 2N3904
R2834 P2.CLKB Net-_Q2325-B_ 10k
Q2293 P1.DN Net-_Q2293-B_ GND 2N3904
R2752 Net-_Q2293-B_ GND 22k
R2838 +5V P2 2.2k
R2839 P2.S1 Net-_Q2327-B_ 10k
R2841 P2.QN Net-_Q2328-B_ 10k
Q2327 P2 Net-_Q2327-B_ Net-_Q2327-E_ 2N3904
R2840 Net-_Q2327-B_ GND 22k
R2750 +5V P1.DN 4.7k
R2751 NX1 Net-_Q2293-B_ 10k
R2591 +5V NX3.t3 4.7k
R2593 Net-_Q2229-B_ GND 22k
Q2229 NX3.t3 Net-_Q2229-B_ Net-_Q2229-E_ 2N3904
R2597 NX3.t0 Net-_Q2231-B_ 10k
R2599 NX3.t1 Net-_Q2232-B_ 10k
R2601 NX3.t2 Net-_Q2233-B_ 10k
R2595 Net-_Q2230-B_ GND 22k
Q2230 Net-_Q2229-E_ Net-_Q2230-B_ GND 2N3904
R2592 IDLE Net-_Q2229-B_ 10k
R2594 P3 Net-_Q2230-B_ 10k
R2753 +5V P1.M1 4.7k
R2757 Net-_Q2295-B_ GND 22k
R2754 NX1 Net-_Q2294-B_ 10k
R2756 P1.CLKN Net-_Q2295-B_ 10k
Q2295 Net-_Q2294-E_ Net-_Q2295-B_ GND 2N3904
Q2294 P1.M1 Net-_Q2294-B_ Net-_Q2294-E_ 2N3904
R2755 Net-_Q2294-B_ GND 22k
R2762 Net-_Q2297-B_ GND 22k
R2759 P1.CLKN Net-_Q2296-B_ 10k
R2761 P1.DN Net-_Q2297-B_ 10k
Q2331 P3.CLKN Net-_Q2331-B_ GND 2N3904
R2848 +5V P3.CLKN 2.2k
R2850 Net-_Q2331-B_ GND 22k
R2849 CK2 Net-_Q2331-B_ 10k
R2758 +5V P1.M2 4.7k
Q2297 Net-_Q2296-E_ Net-_Q2297-B_ GND 2N3904
Q2296 P1.M2 Net-_Q2296-B_ Net-_Q2296-E_ 2N3904
R2760 Net-_Q2296-B_ GND 22k
Q2330 Net-_Q2329-E_ Net-_Q2330-B_ GND 2N3904
R2847 Net-_Q2330-B_ GND 22k
R2843 +5V P2.QN 4.7k
R2931 Net-_Q2362-B_ GND 22k
R2930 P4.MQ Net-_Q2362-B_ 10k
Q2329 P2.QN Net-_Q2329-B_ Net-_Q2329-E_ 2N3904
R2845 Net-_Q2329-B_ GND 22k
R2844 P2 Net-_Q2329-B_ 10k
R2846 P2.S2 Net-_Q2330-B_ 10k
Q2362 P4.MQI Net-_Q2362-B_ GND 2N3904
R2929 +5V P4.MQI 4.7k
R2933 P4.MQ Net-_Q2363-B_ 10k
R2935 P4.CLKB Net-_Q2364-B_ 10k
Q2363 P4.S1 Net-_Q2363-B_ Net-_Q2363-E_ 2N3904
Q2364 Net-_Q2363-E_ Net-_Q2364-B_ GND 2N3904
R2936 Net-_Q2364-B_ GND 22k
R2934 Net-_Q2363-B_ GND 22k
R2932 +5V P4.S1 4.7k
R3082 +5V D5_N 4.7k
Q2422 D5_N Net-_Q2422-B_ Net-_Q2422-E_ 2N3904
R3085 P5 Net-_Q2423-B_ 10k
R3083 OP1BB Net-_Q2422-B_ 10k
R3084 Net-_Q2422-B_ GND 22k
Q2423 Net-_Q2422-E_ Net-_Q2423-B_ GND 2N3904
R3086 Net-_Q2423-B_ GND 22k
R3088 D5_N Net-_Q2424-B_ 10k
Q2425 OUT_B4.CLKN Net-_Q2425-B_ GND 2N3904
R3092 Net-_Q2425-B_ GND 22k
R3091 MEMCLK2 Net-_Q2425-B_ 10k
R3174 +5V OUT_B5.S1 4.7k
R3090 +5V OUT_B4.CLKN 2.2k
R3087 +5V D5 4.7k
Q2424 D5 Net-_Q2424-B_ GND 2N3904
R3089 Net-_Q2424-B_ GND 22k
R3171 +5V OUT_B5.MQI 4.7k
Q2455 Net-_Q2454-E_ Net-_Q2455-B_ GND 2N3904
R3170 Net-_Q2455-B_ GND 22k
R3166 +5V OUT_B5.MQN 4.7k
R3168 Net-_Q2454-B_ GND 22k
Q2454 OUT_B5.MQN Net-_Q2454-B_ Net-_Q2454-E_ 2N3904
R3167 OUT_B5.MQ Net-_Q2454-B_ 10k
R3169 OUT_B5.M2 Net-_Q2455-B_ 10k
Q2456 OUT_B5.MQI Net-_Q2456-B_ GND 2N3904
R3173 Net-_Q2456-B_ GND 22k
R3175 OUT_B5.MQ Net-_Q2457-B_ 10k
R3177 OUT_B5.CLKB Net-_Q2458-B_ 10k
Q2457 OUT_B5.S1 Net-_Q2457-B_ Net-_Q2457-E_ 2N3904
Q2458 Net-_Q2457-E_ Net-_Q2458-B_ GND 2N3904
R3178 Net-_Q2458-B_ GND 22k
R3176 Net-_Q2457-B_ GND 22k
R3172 OUT_B5.MQ Net-_Q2456-B_ 10k
Q2426 OUT_B4.CLKB Net-_Q2426-B_ GND 2N3904
R3095 Net-_Q2426-B_ GND 22k
R3179 +5V OUT_B5.S2 4.7k
R3180 OUT_B5.CLKB Net-_Q2459-B_ 10k
R3182 OUT_B5.MQI Net-_Q2460-B_ 10k
R3183 Net-_Q2460-B_ GND 22k
Q2460 Net-_Q2459-E_ Net-_Q2460-B_ GND 2N3904
Q2459 OUT_B5.S2 Net-_Q2459-B_ Net-_Q2459-E_ 2N3904
R3181 Net-_Q2459-B_ GND 22k
R3093 +5V OUT_B4.CLKB 4.7k
R3094 OUT_B4.CLKN Net-_Q2426-B_ 10k
Q2300 P1.MQN Net-_Q2300-B_ Net-_Q2300-E_ 2N3904
R2770 Net-_Q2300-B_ GND 22k
R2768 +5V P1.MQN 4.7k
Q2302 P1.MQI Net-_Q2302-B_ GND 2N3904
R2775 Net-_Q2302-B_ GND 22k
R2774 P1.MQ Net-_Q2302-B_ 10k
R2773 +5V P1.MQI 4.7k
R2854 +5V P3.DN 4.7k
Q2301 Net-_Q2300-E_ Net-_Q2301-B_ GND 2N3904
R2772 Net-_Q2301-B_ GND 22k
R2857 +5V P3.M1 4.7k
R2765 Net-_Q2298-B_ GND 22k
R2767 Net-_Q2299-B_ GND 22k
Q2299 Net-_Q2298-E_ Net-_Q2299-B_ GND 2N3904
R2764 P1.M1 Net-_Q2298-B_ 10k
R2766 P1.MQN Net-_Q2299-B_ 10k
R2853 Net-_Q2332-B_ GND 22k
R2852 P3.CLKN Net-_Q2332-B_ 10k
Q2332 P3.CLKB Net-_Q2332-B_ GND 2N3904
R2858 NX3 Net-_Q2334-B_ 10k
R2860 P3.CLKN Net-_Q2335-B_ 10k
Q2335 Net-_Q2334-E_ Net-_Q2335-B_ GND 2N3904
R2861 Net-_Q2335-B_ GND 22k
Q2369 P4.QN Net-_Q2369-B_ Net-_Q2369-E_ 2N3904
R2949 Net-_Q2369-B_ GND 22k
R2859 Net-_Q2334-B_ GND 22k
Q2334 P3.M1 Net-_Q2334-B_ Net-_Q2334-E_ 2N3904
R2947 +5V P4.QN 4.7k
Q2370 Net-_Q2369-E_ Net-_Q2370-B_ GND 2N3904
R2951 Net-_Q2370-B_ GND 22k
R2948 P4 Net-_Q2369-B_ 10k
R2950 P4.S2 Net-_Q2370-B_ 10k
Q2367 P4 Net-_Q2367-B_ Net-_Q2367-E_ 2N3904
Q2368 Net-_Q2367-E_ Net-_Q2368-B_ GND 2N3904
R2946 Net-_Q2368-B_ GND 22k
R2944 Net-_Q2367-B_ GND 22k
R2937 +5V P4.S2 4.7k
R2942 +5V P4 2.2k
R2856 Net-_Q2333-B_ GND 22k
R2769 P1.MQ Net-_Q2300-B_ 10k
R2771 P1.M2 Net-_Q2301-B_ 10k
Q2298 P1.MQ Net-_Q2298-B_ Net-_Q2298-E_ 2N3904
R2763 +5V P1.MQ 4.7k
Q2333 P3.DN Net-_Q2333-B_ GND 2N3904
R2851 +5V P3.CLKB 4.7k
R2855 NX3 Net-_Q2333-B_ 10k
R2943 P4.S1 Net-_Q2367-B_ 10k
R2945 P4.QN Net-_Q2368-B_ 10k
R2938 P4.CLKB Net-_Q2365-B_ 10k
R2940 P4.MQI Net-_Q2366-B_ 10k
R2941 Net-_Q2366-B_ GND 22k
Q2366 Net-_Q2365-E_ Net-_Q2366-B_ GND 2N3904
Q2365 P4.S2 Net-_Q2365-B_ Net-_Q2365-E_ 2N3904
R2939 Net-_Q2365-B_ GND 22k
R2547 +5V NX4.t0 4.7k
Q2211 NX4.t0 Net-_Q2211-B_ Net-_Q2211-E_ 2N3904
R2549 Net-_Q2211-B_ GND 22k
R2548 TMB Net-_Q2211-B_ 10k
R2550 S2 Net-_Q2212-B_ 10k
Q2210 Net-_Q2209-E_ Net-_Q2210-B_ GND 2N3904
R2546 Net-_Q2210-B_ GND 22k
Q2209 Net-_Q2208-E_ Net-_Q2209-B_ Net-_Q2209-E_ 2N3904
R2538 +5V NX5 4.7k
Q2207 NX5 Net-_Q2207-B_ Net-_Q2207-E_ 2N3904
Q2208 Net-_Q2207-E_ Net-_Q2208-B_ Net-_Q2208-E_ 2N3904
Q2212 Net-_Q2211-E_ Net-_Q2212-B_ GND 2N3904
R2551 Net-_Q2212-B_ GND 22k
R2666 P1 Net-_Q2260-B_ 10k
R2664 TMB Net-_Q2259-B_ 10k
R2663 +5V NX0.t0 4.7k
Q2259 NX0.t0 Net-_Q2259-B_ Net-_Q2259-E_ 2N3904
R2665 Net-_Q2259-B_ GND 22k
Q2260 Net-_Q2259-E_ Net-_Q2260-B_ GND 2N3904
R2667 Net-_Q2260-B_ GND 22k
R2541 NX5.t1 Net-_Q2208-B_ 10k
R2542 Net-_Q2208-B_ GND 22k
R2540 Net-_Q2207-B_ GND 22k
R2543 NX5.t2 Net-_Q2209-B_ 10k
R2545 NX5.t3 Net-_Q2210-B_ 10k
R2539 NX5.t0 Net-_Q2207-B_ 10k
R2544 Net-_Q2209-B_ GND 22k
R2654 +5V NX1 4.7k
R2658 Net-_Q2256-B_ GND 22k
Q2257 Net-_Q2256-E_ Net-_Q2257-B_ Net-_Q2257-E_ 2N3904
R2660 Net-_Q2257-B_ GND 22k
R2656 Net-_Q2255-B_ GND 22k
Q2255 NX1 Net-_Q2255-B_ Net-_Q2255-E_ 2N3904
Q2256 Net-_Q2255-E_ Net-_Q2256-B_ Net-_Q2256-E_ 2N3904
R2655 NX1.t0 Net-_Q2255-B_ 10k
R2657 NX1.t1 Net-_Q2256-B_ 10k
R2659 NX1.t2 Net-_Q2257-B_ 10k
R2711 +5V P0.MQ 4.7k
R2714 P0.MQN Net-_Q2279-B_ 10k
R2712 P0.M1 Net-_Q2278-B_ 10k
R2706 +5V P0.M2 4.7k
Q2276 P0.M2 Net-_Q2276-B_ Net-_Q2276-E_ 2N3904
R2662 Net-_Q2258-B_ GND 22k
Q2258 Net-_Q2257-E_ Net-_Q2258-B_ GND 2N3904
R2708 Net-_Q2276-B_ GND 22k
R2707 P0.CLKN Net-_Q2276-B_ 10k
R2709 P0.DN Net-_Q2277-B_ 10k
R2661 NX1.t3 Net-_Q2258-B_ 10k
Q2278 P0.MQ Net-_Q2278-B_ Net-_Q2278-E_ 2N3904
R2713 Net-_Q2278-B_ GND 22k
R2634 +5V NX1.t0 4.7k
R2635 TMB Net-_Q2247-B_ 10k
R2637 P2 Net-_Q2248-B_ 10k
R2638 Net-_Q2248-B_ GND 22k
Q2247 NX1.t0 Net-_Q2247-B_ Net-_Q2247-E_ 2N3904
R2636 Net-_Q2247-B_ GND 22k
Q2248 Net-_Q2247-E_ Net-_Q2248-B_ GND 2N3904
R2639 +5V NX1.t1 4.7k
Q2249 NX1.t1 Net-_Q2249-B_ Net-_Q2249-E_ 2N3904
R2640 TDB Net-_Q2249-B_ 10k
R2642 P0 Net-_Q2250-B_ 10k
Q2250 Net-_Q2249-E_ Net-_Q2250-B_ GND 2N3904
R2643 Net-_Q2250-B_ GND 22k
R2641 Net-_Q2249-B_ GND 22k
R2650 LB Net-_Q2253-B_ 10k
R2652 A1 Net-_Q2254-B_ 10k
R2651 Net-_Q2253-B_ GND 22k
R2653 Net-_Q2254-B_ GND 22k
R2649 +5V NX1.t3 4.7k
Q2253 NX1.t3 Net-_Q2253-B_ Net-_Q2253-E_ 2N3904
Q2254 Net-_Q2253-E_ Net-_Q2254-B_ GND 2N3904
Q2197 Net-_Q2196-E_ Net-_Q2197-B_ GND 2N3904
R2514 Net-_Q2197-B_ GND 22k
R2512 Net-_Q2196-B_ GND 22k
R2513 BZ Net-_Q2197-B_ 10k
R2529 TDNQ Net-_Q2203-B_ 10k
R2531 P4 Net-_Q2204-B_ 10k
R2532 Net-_Q2204-B_ GND 22k
R2530 Net-_Q2203-B_ GND 22k
Q2204 Net-_Q2203-E_ Net-_Q2204-B_ GND 2N3904
Q2203 NX5.t2 Net-_Q2203-B_ Net-_Q2203-E_ 2N3904
R2528 +5V NX5.t2 4.7k
R2536 P5 Net-_Q2206-B_ 10k
R2534 IDLE Net-_Q2205-B_ 10k
R2537 Net-_Q2206-B_ GND 22k
Q2206 Net-_Q2205-E_ Net-_Q2206-B_ GND 2N3904
R2535 Net-_Q2205-B_ GND 22k
Q2205 NX5.t3 Net-_Q2205-B_ Net-_Q2205-E_ 2N3904
R2533 +5V NX5.t3 4.7k
R2648 Net-_Q2252-B_ GND 22k
Q2252 Net-_Q2251-E_ Net-_Q2252-B_ GND 2N3904
R2646 Net-_Q2251-B_ GND 22k
R2644 +5V NX1.t2 4.7k
Q2251 NX1.t2 Net-_Q2251-B_ Net-_Q2251-E_ 2N3904
R2645 IDLE Net-_Q2251-B_ 10k
R2647 P1 Net-_Q2252-B_ 10k
R2503 ENCB_N2 Net-_Q2193-B_ 10k
R2502 Net-_Q2192-B_ GND 22k
Q2193 Net-_Q2192-E_ Net-_Q2193-B_ GND 2N3904
R2504 Net-_Q2193-B_ GND 22k
R2524 TDQ Net-_Q2201-B_ 10k
R2526 S2 Net-_Q2202-B_ 10k
R2518 +5V NX5.t0 4.7k
Q2199 NX5.t0 Net-_Q2199-B_ Net-_Q2199-E_ 2N3904
R2520 Net-_Q2199-B_ GND 22k
R2519 TMB Net-_Q2199-B_ 10k
R2521 S3 Net-_Q2200-B_ 10k
Q2200 Net-_Q2199-E_ Net-_Q2200-B_ GND 2N3904
R2522 Net-_Q2200-B_ GND 22k
R2527 Net-_Q2202-B_ GND 22k
Q2202 Net-_Q2201-E_ Net-_Q2202-B_ GND 2N3904
Q2201 NX5.t1 Net-_Q2201-B_ Net-_Q2201-E_ 2N3904
R2525 Net-_Q2201-B_ GND 22k
R2523 +5V NX5.t1 4.7k
R2971 +5V P5.MQ 4.7k
R2972 P5.M1 Net-_Q2378-B_ 10k
R2974 P5.MQN Net-_Q2379-B_ 10k
Q2378 P5.MQ Net-_Q2378-B_ Net-_Q2378-E_ 2N3904
Q2379 Net-_Q2378-E_ Net-_Q2379-B_ GND 2N3904
R2975 Net-_Q2379-B_ GND 22k
R2973 Net-_Q2378-B_ GND 22k
R2966 +5V P5.M2 4.7k
R2967 P5.CLKN Net-_Q2376-B_ 10k
R2969 P5.DN Net-_Q2377-B_ 10k
R2970 Net-_Q2377-B_ GND 22k
Q2377 Net-_Q2376-E_ Net-_Q2377-B_ GND 2N3904
Q2376 P5.M2 Net-_Q2376-B_ Net-_Q2376-E_ 2N3904
R2968 Net-_Q2376-B_ GND 22k
Q2375 Net-_Q2374-E_ Net-_Q2375-B_ GND 2N3904
R2965 Net-_Q2375-B_ GND 22k
R2964 P5.CLKN Net-_Q2375-B_ 10k
R2880 +5V P3.S1 4.7k
Q2343 P3.S1 Net-_Q2343-B_ Net-_Q2343-E_ 2N3904
R2882 Net-_Q2343-B_ GND 22k
R2881 P3.MQ Net-_Q2343-B_ 10k
R2883 P3.CLKB Net-_Q2344-B_ 10k
R2884 Net-_Q2344-B_ GND 22k
Q2344 Net-_Q2343-E_ Net-_Q2344-B_ GND 2N3904
Q2279 Net-_Q2278-E_ Net-_Q2279-B_ GND 2N3904
R2715 Net-_Q2279-B_ GND 22k
R2799 +5V P2.CLKB 4.7k
Q2277 Net-_Q2276-E_ Net-_Q2277-B_ GND 2N3904
R2710 Net-_Q2277-B_ GND 22k
R2797 CK2 Net-_Q2311-B_ 10k
Q2311 P2.CLKN Net-_Q2311-B_ GND 2N3904
R2798 Net-_Q2311-B_ GND 22k
R2796 +5V P2.CLKN 2.2k
R2885 +5V P3.S2 4.7k
R2886 P3.CLKB Net-_Q2345-B_ 10k
R2888 P3.MQI Net-_Q2346-B_ 10k
Q2345 P3.S2 Net-_Q2345-B_ Net-_Q2345-E_ 2N3904
Q2346 Net-_Q2345-E_ Net-_Q2346-B_ GND 2N3904
R2889 Net-_Q2346-B_ GND 22k
R2887 Net-_Q2345-B_ GND 22k
R2801 Net-_Q2312-B_ GND 22k
Q2312 P2.CLKB Net-_Q2312-B_ GND 2N3904
R2800 P2.CLKN Net-_Q2312-B_ 10k
R2790 Net-_Q2308-B_ GND 22k
R2872 +5V P3.MQN 4.7k
Q2342 P3.MQI Net-_Q2342-B_ GND 2N3904
R2879 Net-_Q2342-B_ GND 22k
R2961 +5V P5.M1 4.7k
Q2374 P5.M1 Net-_Q2374-B_ Net-_Q2374-E_ 2N3904
R2963 Net-_Q2374-B_ GND 22k
R2962 NX5 Net-_Q2374-B_ 10k
R2960 Net-_Q2373-B_ GND 22k
R2878 P3.MQ Net-_Q2342-B_ 10k
R2877 +5V P3.MQI 4.7k
R2795 Net-_Q2310-B_ GND 22k
Q2373 P5.DN Net-_Q2373-B_ GND 2N3904
R2958 +5V P5.DN 4.7k
R2873 P3.MQ Net-_Q2340-B_ 10k
R2875 P3.M2 Net-_Q2341-B_ 10k
R2874 Net-_Q2340-B_ GND 22k
Q2340 P3.MQN Net-_Q2340-B_ Net-_Q2340-E_ 2N3904
R2876 Net-_Q2341-B_ GND 22k
Q2341 Net-_Q2340-E_ Net-_Q2341-B_ GND 2N3904
R2959 NX5 Net-_Q2373-B_ 10k
R2867 +5V P3.MQ 4.7k
R2957 Net-_Q2372-B_ GND 22k
R2956 P5.CLKN Net-_Q2372-B_ 10k
R2868 P3.M1 Net-_Q2338-B_ 10k
R2870 P3.MQN Net-_Q2339-B_ 10k
Q2339 Net-_Q2338-E_ Net-_Q2339-B_ GND 2N3904
Q2338 P3.MQ Net-_Q2338-B_ Net-_Q2338-E_ 2N3904
R2869 Net-_Q2338-B_ GND 22k
R2871 Net-_Q2339-B_ GND 22k
Q2372 P5.CLKB Net-_Q2372-B_ GND 2N3904
R2955 +5V P5.CLKB 4.7k
R2785 Net-_Q2306-B_ GND 22k
R2864 Net-_Q2336-B_ GND 22k
Q2336 P3.M2 Net-_Q2336-B_ Net-_Q2336-E_ 2N3904
R2866 Net-_Q2337-B_ GND 22k
Q2337 Net-_Q2336-E_ Net-_Q2337-B_ GND 2N3904
R2862 +5V P3.M2 4.7k
Q2371 P5.CLKN Net-_Q2371-B_ GND 2N3904
R2952 +5V P5.CLKN 2.2k
R2863 P3.CLKN Net-_Q2336-B_ 10k
R2865 P3.DN Net-_Q2337-B_ 10k
R2780 Net-_Q2304-B_ GND 22k
R2953 CK2 Net-_Q2371-B_ 10k
R2954 Net-_Q2371-B_ GND 22k
R2781 +5V P1.S2 4.7k
R2777 P1.MQ Net-_Q2303-B_ 10k
R2779 P1.CLKB Net-_Q2304-B_ 10k
R2782 P1.CLKB Net-_Q2305-B_ 10k
Q2305 P1.S2 Net-_Q2305-B_ Net-_Q2305-E_ 2N3904
R2783 Net-_Q2305-B_ GND 22k
Q2306 Net-_Q2305-E_ Net-_Q2306-B_ GND 2N3904
R2784 P1.MQI Net-_Q2306-B_ 10k
Q2304 Net-_Q2303-E_ Net-_Q2304-B_ GND 2N3904
R2778 Net-_Q2303-B_ GND 22k
Q2303 P1.S1 Net-_Q2303-B_ Net-_Q2303-E_ 2N3904
R2776 +5V P1.S1 4.7k
R2786 +5V P1 2.2k
R2787 P1.S1 Net-_Q2307-B_ 10k
R2789 P1.QN Net-_Q2308-B_ 10k
Q2307 P1 Net-_Q2307-B_ Net-_Q2307-E_ 2N3904
R2788 Net-_Q2307-B_ GND 22k
Q2308 Net-_Q2307-E_ Net-_Q2308-B_ GND 2N3904
R2701 +5V P0.M1 4.7k
R2696 P0.CLKN Net-_Q2272-B_ 10k
R2702 NX0 Net-_Q2274-B_ 10k
R2704 P0.CLKN Net-_Q2275-B_ 10k
Q2271 P0.CLKN Net-_Q2271-B_ GND 2N3904
R2694 Net-_Q2271-B_ GND 22k
R2693 CK2 Net-_Q2271-B_ 10k
Q2275 Net-_Q2274-E_ Net-_Q2275-B_ GND 2N3904
R2705 Net-_Q2275-B_ GND 22k
R2703 Net-_Q2274-B_ GND 22k
Q2274 P0.M1 Net-_Q2274-B_ Net-_Q2274-E_ 2N3904
R2692 +5V P0.CLKN 2.2k
Q2272 P0.CLKB Net-_Q2272-B_ GND 2N3904
R2697 Net-_Q2272-B_ GND 22k
R2699 NX0 Net-_Q2273-B_ 10k
R2698 +5V P0.DN 4.7k
Q2273 P0.DN Net-_Q2273-B_ GND 2N3904
R2700 Net-_Q2273-B_ GND 22k
R2695 +5V P0.CLKB 4.7k
R2792 P1 Net-_Q2309-B_ 10k
R2794 P1.S2 Net-_Q2310-B_ 10k
Q2309 P1.QN Net-_Q2309-B_ Net-_Q2309-E_ 2N3904
R2793 Net-_Q2309-B_ GND 22k
Q2310 Net-_Q2309-E_ Net-_Q2310-B_ GND 2N3904
R2791 +5V P1.QN 4.7k
R2150 +5V T1.S1 4.7k
Q2056 T1.S1 Net-_Q2056-B_ Net-_Q2056-E_ 2N3904
R2152 Net-_Q2056-B_ GND 22k
Q2057 Net-_Q2056-E_ Net-_Q2057-B_ GND 2N3904
R2153 T1.CLKB Net-_Q2057-B_ 10k
R2073 Net-_Q2026-B_ GND 22k
R2151 T1.MQ Net-_Q2056-B_ 10k
R2348 Net-_Q2132-B_ GND 22k
Q2132 TMA Net-_Q2132-B_ GND 2N3904
R2255 T3.MQ Net-_Q2096-B_ 10k
R2257 T3.CLKB Net-_Q2097-B_ 10k
R2258 Net-_Q2097-B_ GND 22k
Q2097 Net-_Q2096-E_ Net-_Q2097-B_ GND 2N3904
R2347 TM_N Net-_Q2132-B_ 10k
R2346 +5V TMA 4.7k
R2161 T1.S1 Net-_Q2060-B_ 10k
R2163 T1.QN Net-_Q2061-B_ 10k
R2155 +5V T1.S2 4.7k
R2156 T1.CLKB Net-_Q2058-B_ 10k
Q2058 T1.S2 Net-_Q2058-B_ Net-_Q2058-E_ 2N3904
R2157 Net-_Q2058-B_ GND 22k
R2158 T1.MQI Net-_Q2059-B_ 10k
Q2059 Net-_Q2058-E_ Net-_Q2059-B_ GND 2N3904
R2162 Net-_Q2060-B_ GND 22k
Q2060 T1 Net-_Q2060-B_ Net-_Q2060-E_ 2N3904
Q2061 Net-_Q2060-E_ Net-_Q2061-B_ GND 2N3904
R2165 +5V T1.QN 4.7k
R2170 +5V T2.CLKN 2.2k
R2078 Net-_Q2028-B_ GND 22k
R2160 +5V T1 2.2k
R2168 T1.S2 Net-_Q2063-B_ 10k
R2166 T1 Net-_Q2062-B_ 10k
Q2062 T1.QN Net-_Q2062-B_ Net-_Q2062-E_ 2N3904
R2167 Net-_Q2062-B_ GND 22k
R2083 Net-_Q2030-B_ GND 22k
R2088 Net-_Q2032-B_ GND 22k
Q2063 Net-_Q2062-E_ Net-_Q2063-B_ GND 2N3904
R2254 +5V T3.S1 4.7k
Q2096 T3.S1 Net-_Q2096-B_ Net-_Q2096-E_ 2N3904
R2256 Net-_Q2096-B_ GND 22k
Q2064 T2.CLKN Net-_Q2064-B_ GND 2N3904
R2172 Net-_Q2064-B_ GND 22k
R2171 CK1 Net-_Q2064-B_ 10k
R2236 +5V T3.M2 4.7k
R2240 Net-_Q2090-B_ GND 22k
R2237 T3.CLKN Net-_Q2089-B_ 10k
R2239 T3.DN Net-_Q2090-B_ 10k
Q2090 Net-_Q2089-E_ Net-_Q2090-B_ GND 2N3904
Q2089 T3.M2 Net-_Q2089-B_ Net-_Q2089-E_ 2N3904
R2238 Net-_Q2089-B_ GND 22k
R2154 Net-_Q2057-B_ GND 22k
R2169 Net-_Q2063-B_ GND 22k
R2251 +5V T3.MQI 4.7k
R2246 +5V T3.MQN 4.7k
R2247 T3.MQ Net-_Q2093-B_ 10k
R2164 Net-_Q2061-B_ GND 22k
R2241 +5V T3.MQ 4.7k
R2159 Net-_Q2059-B_ GND 22k
Q2092 Net-_Q2091-E_ Net-_Q2092-B_ GND 2N3904
Q2091 T3.MQ Net-_Q2091-B_ Net-_Q2091-E_ 2N3904
R2243 Net-_Q2091-B_ GND 22k
R2245 Net-_Q2092-B_ GND 22k
R2333 +5V T 2.2k
R2242 T3.M1 Net-_Q2091-B_ 10k
R2244 T3.MQN Net-_Q2092-B_ 10k
Q2127 T Net-_Q2127-B_ GND 2N3904
R2335 Net-_Q2127-B_ GND 22k
R2331 T3 Net-_Q2126-B_ 10k
R2329 T2 Net-_Q2125-B_ 10k
R2330 Net-_Q2125-B_ GND 22k
Q2125 T_N Net-_Q2125-B_ GND 2N3904
R2328 Net-_Q2124-B_ GND 22k
Q2126 T_N Net-_Q2126-B_ GND 2N3904
R2332 Net-_Q2126-B_ GND 22k
R2327 T1 Net-_Q2124-B_ 10k
R2334 T_N Net-_Q2127-B_ 10k
Q2124 T_N Net-_Q2124-B_ GND 2N3904
R2326 +5V T_N 4.7k
R2349 +5V TMB 2.2k
Q2133 TMB Net-_Q2133-B_ GND 2N3904
Q2098 T3.S2 Net-_Q2098-B_ Net-_Q2098-E_ 2N3904
R2260 T3.CLKB Net-_Q2098-B_ 10k
R2262 T3.MQI Net-_Q2099-B_ 10k
R2261 Net-_Q2098-B_ GND 22k
Q2099 Net-_Q2098-E_ Net-_Q2099-B_ GND 2N3904
R2263 Net-_Q2099-B_ GND 22k
R2351 Net-_Q2133-B_ GND 22k
R2350 TM_N Net-_Q2133-B_ 10k
R2268 Net-_Q2101-B_ GND 22k
Q2135 Net-_Q2134-E_ Net-_Q2135-B_ GND 2N3904
R2352 +5V TD_N 4.7k
Q2134 TD_N Net-_Q2134-B_ Net-_Q2134-E_ 2N3904
R2354 Net-_Q2134-B_ GND 22k
R2353 T Net-_Q2134-B_ 10k
R2355 OP0 Net-_Q2135-B_ 10k
R2264 +5V T3 2.2k
Q2100 T3 Net-_Q2100-B_ Net-_Q2100-E_ 2N3904
R2266 Net-_Q2100-B_ GND 22k
Q2101 Net-_Q2100-E_ Net-_Q2101-B_ GND 2N3904
R2265 T3.S1 Net-_Q2100-B_ 10k
R2267 T3.QN Net-_Q2101-B_ 10k
R2270 T3 Net-_Q2102-B_ 10k
R2272 T3.S2 Net-_Q2103-B_ 10k
Q2103 Net-_Q2102-E_ Net-_Q2103-B_ GND 2N3904
R2273 Net-_Q2103-B_ GND 22k
R2359 Net-_Q2136-B_ GND 22k
R2358 TD_N Net-_Q2136-B_ 10k
Q2102 T3.QN Net-_Q2102-B_ Net-_Q2102-E_ 2N3904
R2271 Net-_Q2102-B_ GND 22k
R2357 +5V TDA 4.7k
Q2136 TDA Net-_Q2136-B_ GND 2N3904
R2182 T2.CLKN Net-_Q2068-B_ 10k
R2269 +5V T3.QN 4.7k
Q2068 Net-_Q2067-E_ Net-_Q2068-B_ GND 2N3904
R2183 Net-_Q2068-B_ GND 22k
R2180 T1 Net-_Q2067-B_ 10k
Q2067 T2.M1 Net-_Q2067-B_ Net-_Q2067-E_ 2N3904
R2181 Net-_Q2067-B_ GND 22k
R2259 +5V T3.S2 4.7k
R2178 Net-_Q2066-B_ GND 22k
Q2066 T2.DN Net-_Q2066-B_ GND 2N3904
R2177 T1 Net-_Q2066-B_ 10k
R2176 +5V T2.DN 4.7k
R2173 +5V T2.CLKB 4.7k
R2174 T2.CLKN Net-_Q2065-B_ 10k
Q2065 T2.CLKB Net-_Q2065-B_ GND 2N3904
R2175 Net-_Q2065-B_ GND 22k
R2463 +5V A2 2.2k
R2469 Net-_Q2179-B_ GND 22k
Q2179 Net-_Q2178-E_ Net-_Q2179-B_ GND 2N3904
R2464 AK_N2 Net-_Q2177-B_ 10k
R2466 AM_N2 Net-_Q2178-B_ 10k
R2465 Net-_Q2177-B_ GND 22k
Q2177 A2 Net-_Q2177-B_ Net-_Q2177-E_ 2N3904
Q2178 Net-_Q2177-E_ Net-_Q2178-B_ Net-_Q2178-E_ 2N3904
R2467 Net-_Q2178-B_ GND 22k
R2468 AD_N2 Net-_Q2179-B_ 10k
R2438 +5V A1 2.2k
R2439 AK_N1 Net-_Q2167-B_ 10k
R2441 AM_N1 Net-_Q2168-B_ 10k
R2440 Net-_Q2167-B_ GND 22k
Q2167 A1 Net-_Q2167-B_ Net-_Q2167-E_ 2N3904
R2444 Net-_Q2169-B_ GND 22k
Q2169 Net-_Q2168-E_ Net-_Q2169-B_ GND 2N3904
Q2168 Net-_Q2167-E_ Net-_Q2168-B_ Net-_Q2168-E_ 2N3904
R2442 Net-_Q2168-B_ GND 22k
R2443 AD_N1 Net-_Q2169-B_ 10k
R2446 ENCA_N2 Net-_Q2170-B_ 10k
R2458 +5V AD_N2 4.7k
R2459 TDA Net-_Q2175-B_ 10k
R2461 P4 Net-_Q2176-B_ 10k
R2462 Net-_Q2176-B_ GND 22k
Q2175 AD_N2 Net-_Q2175-B_ Net-_Q2175-E_ 2N3904
R2460 Net-_Q2175-B_ GND 22k
Q2176 Net-_Q2175-E_ Net-_Q2176-B_ GND 2N3904
R2448 +5V AK_N2 4.7k
R2449 KSEL Net-_Q2171-B_ 10k
R2451 KA2 Net-_Q2172-B_ 10k
R2452 Net-_Q2172-B_ GND 22k
Q2171 AK_N2 Net-_Q2171-B_ Net-_Q2171-E_ 2N3904
R2450 Net-_Q2171-B_ GND 22k
Q2172 Net-_Q2171-E_ Net-_Q2172-B_ GND 2N3904
R2445 +5V KA2 4.7k
R2447 Net-_Q2170-B_ GND 22k
Q2170 KA2 Net-_Q2170-B_ GND 2N3904
R2453 +5V AM_N2 4.7k
R2454 TMA Net-_Q2173-B_ 10k
R2456 P5 Net-_Q2174-B_ 10k
R2457 Net-_Q2174-B_ GND 22k
Q2173 AM_N2 Net-_Q2173-B_ Net-_Q2173-E_ 2N3904
R2455 Net-_Q2173-B_ GND 22k
Q2174 Net-_Q2173-E_ Net-_Q2174-B_ GND 2N3904
Q2069 T2.M2 Net-_Q2069-B_ Net-_Q2069-E_ 2N3904
R2184 +5V T2.M2 4.7k
R2187 T2.DN Net-_Q2070-B_ 10k
R2188 Net-_Q2070-B_ GND 22k
Q2070 Net-_Q2069-E_ Net-_Q2070-B_ GND 2N3904
R2186 Net-_Q2069-B_ GND 22k
R2274 +5V DN.CLKN 2.2k
R2275 CK1 Net-_Q2104-B_ 10k
R2179 +5V T2.M1 4.7k
R2185 T2.CLKN Net-_Q2069-B_ 10k
R2278 DN.CLKN Net-_Q2105-B_ 10k
R2363 +5V Q_N 4.7k
R2193 Net-_Q2072-B_ GND 22k
Q2072 Net-_Q2071-E_ Net-_Q2072-B_ GND 2N3904
Q2104 DN.CLKN Net-_Q2104-B_ GND 2N3904
R2276 Net-_Q2104-B_ GND 22k
R2367 Net-_Q2139-B_ GND 22k
Q2139 Q_N Net-_Q2139-B_ GND 2N3904
Q2138 Q_N Net-_Q2138-B_ GND 2N3904
R2365 Net-_Q2138-B_ GND 22k
R2364 P5 Net-_Q2138-B_ 10k
R2366 S3 Net-_Q2139-B_ 10k
R2279 Net-_Q2105-B_ GND 22k
Q2105 DN.CLKB Net-_Q2105-B_ GND 2N3904
R2277 +5V DN.CLKB 4.7k
R2101 Net-_Q2037-B_ GND 22k
R2189 +5V T2.MQ 4.7k
Q2071 T2.MQ Net-_Q2071-B_ Net-_Q2071-E_ 2N3904
R2191 Net-_Q2071-B_ GND 22k
R2190 T2.M1 Net-_Q2071-B_ 10k
R2192 T2.MQN Net-_Q2072-B_ 10k
R2106 Net-_Q2039-B_ GND 22k
R2111 Net-_Q2041-B_ GND 22k
R2096 Net-_Q2035-B_ GND 22k
R2356 Net-_Q2135-B_ GND 22k
R2360 +5V TDB 2.2k
Q2137 TDB Net-_Q2137-B_ GND 2N3904
R2362 Net-_Q2137-B_ GND 22k
R2361 TD_N Net-_Q2137-B_ 10k
Q2095 T3.MQI Net-_Q2095-B_ GND 2N3904
R2252 T3.MQ Net-_Q2095-B_ 10k
R2253 Net-_Q2095-B_ GND 22k
R2341 +5V TM_N 4.7k
Q2130 TM_N Net-_Q2130-B_ Net-_Q2130-E_ 2N3904
Q2129 IDLE Net-_Q2129-B_ GND 2N3904
R2340 Net-_Q2129-B_ GND 22k
R2248 Net-_Q2093-B_ GND 22k
Q2093 T3.MQN Net-_Q2093-B_ Net-_Q2093-E_ 2N3904
R2342 T Net-_Q2130-B_ 10k
Q2131 Net-_Q2130-E_ Net-_Q2131-B_ GND 2N3904
R2345 Net-_Q2131-B_ GND 22k
R2343 Net-_Q2130-B_ GND 22k
R2344 OP0N Net-_Q2131-B_ 10k
R2249 T3.M2 Net-_Q2094-B_ 10k
Q2094 Net-_Q2093-E_ Net-_Q2094-B_ GND 2N3904
R2250 Net-_Q2094-B_ GND 22k
R2336 +5V IDLE 2.2k
Q2128 IDLE Net-_Q2128-B_ GND 2N3904
R2337 L Net-_Q2128-B_ 10k
R2339 T Net-_Q2129-B_ 10k
R2338 Net-_Q2128-B_ GND 22k
R2424 KSEL Net-_Q2161-B_ 10k
R2426 KA1 Net-_Q2162-B_ 10k
Q2161 AK_N1 Net-_Q2161-B_ Net-_Q2161-E_ 2N3904
R2425 Net-_Q2161-B_ GND 22k
R2429 TMA Net-_Q2163-B_ 10k
R2431 P4 Net-_Q2164-B_ 10k
R2423 +5V AK_N1 4.7k
R2427 Net-_Q2162-B_ GND 22k
Q2162 Net-_Q2161-E_ Net-_Q2162-B_ GND 2N3904
R2420 +5V KA1 4.7k
R2421 ENCA_N1 Net-_Q2160-B_ 10k
Q2160 KA1 Net-_Q2160-B_ GND 2N3904
R2422 Net-_Q2160-B_ GND 22k
Q2163 AM_N1 Net-_Q2163-B_ Net-_Q2163-E_ 2N3904
R2430 Net-_Q2163-B_ GND 22k
R2434 TDA Net-_Q2165-B_ 10k
R2436 P3 Net-_Q2166-B_ 10k
Q2166 Net-_Q2165-E_ Net-_Q2166-B_ GND 2N3904
R2437 Net-_Q2166-B_ GND 22k
R2433 +5V AD_N1 4.7k
R2435 Net-_Q2165-B_ GND 22k
Q2165 AD_N1 Net-_Q2165-B_ Net-_Q2165-E_ 2N3904
R2428 +5V AM_N1 4.7k
Q2164 Net-_Q2163-E_ Net-_Q2164-B_ GND 2N3904
R2432 Net-_Q2164-B_ GND 22k
R2021 +5V SIGN_ 4.7k
Q2007 SIGN_ Net-_Q2007-B_ GND 2N3904
R2023 Net-_Q2007-B_ GND 22k
Q2008 SIGB Net-_Q2008-B_ GND 2N3904
R2026 Net-_Q2008-B_ GND 22k
R2022 SIG Net-_Q2007-B_ 10k
R2025 SIGN_ Net-_Q2008-B_ 10k
R2074 +5V L.M2 4.7k
Q2026 Net-_Q2025-E_ Net-_Q2026-B_ GND 2N3904
R2071 Net-_Q2025-B_ GND 22k
R2075 L.CLKN Net-_Q2027-B_ 10k
R2077 L.DN Net-_Q2028-B_ 10k
R2076 Net-_Q2027-B_ GND 22k
Q2027 L.M2 Net-_Q2027-B_ Net-_Q2027-E_ 2N3904
Q2028 Net-_Q2027-E_ Net-_Q2028-B_ GND 2N3904
R2069 +5V L.M1 4.7k
Q2025 L.M1 Net-_Q2025-B_ Net-_Q2025-E_ 2N3904
R2024 +5V SIGB 2.2k
R2027 +5V SIGB2 4.7k
Q2009 SIGB2 Net-_Q2009-B_ GND 2N3904
R2029 Net-_Q2009-B_ GND 22k
R2028 SIGN_ Net-_Q2009-B_ 10k
R2079 +5V L.MQ 4.7k
Q2030 Net-_Q2029-E_ Net-_Q2030-B_ GND 2N3904
Q2029 L.MQ Net-_Q2029-B_ Net-_Q2029-E_ 2N3904
R2081 Net-_Q2029-B_ GND 22k
R2085 L.MQ Net-_Q2031-B_ 10k
R2087 L.M2 Net-_Q2032-B_ 10k
R2086 Net-_Q2031-B_ GND 22k
Q2032 Net-_Q2031-E_ Net-_Q2032-B_ GND 2N3904
Q2031 L.MQN Net-_Q2031-B_ Net-_Q2031-E_ 2N3904
R2084 +5V L.MQN 4.7k
R2080 L.M1 Net-_Q2029-B_ 10k
R2082 L.MQN Net-_Q2030-B_ 10k
R2018 +5V OP1BB 2.2k
Q2006 OP1BB Net-_Q2006-B_ GND 2N3904
R2020 Net-_Q2006-B_ GND 22k
R2070 L_D Net-_Q2025-B_ 10k
R2072 L.CLKN Net-_Q2026-B_ 10k
R2019 OP1NB Net-_Q2006-B_ 10k
R2092 +5V L.S1 4.7k
R2093 L.MQ Net-_Q2034-B_ 10k
R2095 L.CLKB Net-_Q2035-B_ 10k
R2094 Net-_Q2034-B_ GND 22k
Q2034 L.S1 Net-_Q2034-B_ Net-_Q2034-E_ 2N3904
Q2035 Net-_Q2034-E_ Net-_Q2035-B_ GND 2N3904
R2089 +5V L.MQI 4.7k
Q2033 L.MQI Net-_Q2033-B_ GND 2N3904
R2091 Net-_Q2033-B_ GND 22k
R2090 L.MQ Net-_Q2033-B_ 10k
R2378 Net-_Q2143-B_ GND 22k
R2377 TDQ_N Net-_Q2143-B_ 10k
Q2109 DN.M2 Net-_Q2109-B_ Net-_Q2109-E_ 2N3904
R2289 DN.CLKN Net-_Q2109-B_ 10k
R2291 DN.DN Net-_Q2110-B_ 10k
Q2143 TDQ Net-_Q2143-B_ GND 2N3904
R2376 +5V TDQ 4.7k
R2292 Net-_Q2110-B_ GND 22k
R2290 Net-_Q2109-B_ GND 22k
Q2110 Net-_Q2109-E_ Net-_Q2110-B_ GND 2N3904
R2206 Net-_Q2077-B_ GND 22k
R2288 +5V DN.M2 4.7k
R2293 +5V DN.MQ 4.7k
R2294 DN.M1 Net-_Q2111-B_ 10k
R2296 DN.MQN Net-_Q2112-B_ 10k
Q2111 DN.MQ Net-_Q2111-B_ Net-_Q2111-E_ 2N3904
R2295 Net-_Q2111-B_ GND 22k
R2211 Net-_Q2079-B_ GND 22k
R2298 +5V DN.MQN 4.7k
R2299 DN.MQ Net-_Q2113-B_ 10k
R2301 DN.M2 Net-_Q2114-B_ 10k
R2300 Net-_Q2113-B_ GND 22k
Q2113 DN.MQN Net-_Q2113-B_ Net-_Q2113-E_ 2N3904
R2385 TDNQ_N Net-_Q2146-B_ 10k
R2302 Net-_Q2114-B_ GND 22k
Q2114 Net-_Q2113-E_ Net-_Q2114-B_ GND 2N3904
R2384 +5V TDNQ 4.7k
Q2146 TDNQ Net-_Q2146-B_ GND 2N3904
R2386 Net-_Q2146-B_ GND 22k
R2216 Net-_Q2081-B_ GND 22k
Q2112 Net-_Q2111-E_ Net-_Q2112-B_ GND 2N3904
R2297 Net-_Q2112-B_ GND 22k
Q2145 Net-_Q2144-E_ Net-_Q2145-B_ GND 2N3904
R2383 Net-_Q2145-B_ GND 22k
R2379 +5V TDNQ_N 4.7k
R2380 TDB Net-_Q2144-B_ 10k
R2382 Q_N Net-_Q2145-B_ 10k
Q2144 TDNQ_N Net-_Q2144-B_ Net-_Q2144-E_ 2N3904
R2381 Net-_Q2144-B_ GND 22k
R2212 +5V T2 2.2k
R2213 T2.S1 Net-_Q2080-B_ 10k
R2215 T2.QN Net-_Q2081-B_ 10k
Q2080 T2 Net-_Q2080-B_ Net-_Q2080-E_ 2N3904
R2214 Net-_Q2080-B_ GND 22k
Q2081 Net-_Q2080-E_ Net-_Q2081-B_ GND 2N3904
R2121 +5V T1.CLKB 4.7k
Q2045 T1.CLKB Net-_Q2045-B_ GND 2N3904
R2123 Net-_Q2045-B_ GND 22k
R2122 T1.CLKN Net-_Q2045-B_ 10k
R2124 +5V T1.DN 4.7k
Q2046 T1.DN Net-_Q2046-B_ GND 2N3904
R2126 Net-_Q2046-B_ GND 22k
R2125 L Net-_Q2046-B_ 10k
R2119 CK1 Net-_Q2044-B_ 10k
R2202 +5V T2.S1 4.7k
R2205 T2.CLKB Net-_Q2077-B_ 10k
Q2077 Net-_Q2076-E_ Net-_Q2077-B_ GND 2N3904
Q2076 T2.S1 Net-_Q2076-B_ Net-_Q2076-E_ 2N3904
R2204 Net-_Q2076-B_ GND 22k
R2118 +5V T1.CLKN 2.2k
Q2044 T1.CLKN Net-_Q2044-B_ GND 2N3904
R2120 Net-_Q2044-B_ GND 22k
R2203 T2.MQ Net-_Q2076-B_ 10k
R2207 +5V T2.S2 4.7k
R2208 T2.CLKB Net-_Q2078-B_ 10k
R2210 T2.MQI Net-_Q2079-B_ 10k
Q2078 T2.S2 Net-_Q2078-B_ Net-_Q2078-E_ 2N3904
R2209 Net-_Q2078-B_ GND 22k
Q2079 Net-_Q2078-E_ Net-_Q2079-B_ GND 2N3904
R2194 +5V T2.MQN 4.7k
R2195 T2.MQ Net-_Q2073-B_ 10k
R2197 T2.M2 Net-_Q2074-B_ 10k
Q2073 T2.MQN Net-_Q2073-B_ Net-_Q2073-E_ 2N3904
R2196 Net-_Q2073-B_ GND 22k
Q2074 Net-_Q2073-E_ Net-_Q2074-B_ GND 2N3904
R2198 Net-_Q2074-B_ GND 22k
R2280 +5V DN.DN 4.7k
R2284 T3 Net-_Q2107-B_ 10k
R2286 DN.CLKN Net-_Q2108-B_ 10k
R2283 +5V DN.M1 4.7k
Q2075 T2.MQI Net-_Q2075-B_ GND 2N3904
R2201 Net-_Q2075-B_ GND 22k
Q2107 DN.M1 Net-_Q2107-B_ Net-_Q2107-E_ 2N3904
R2285 Net-_Q2107-B_ GND 22k
R2199 +5V T2.MQI 4.7k
R2200 T2.MQ Net-_Q2075-B_ 10k
R2112 +5V L_N 4.7k
Q2042 L_N Net-_Q2042-B_ GND 2N3904
R2114 Net-_Q2042-B_ GND 22k
R2115 +5V LB 2.2k
R2117 Net-_Q2043-B_ GND 22k
Q2043 LB Net-_Q2043-B_ GND 2N3904
R2116 L_N Net-_Q2043-B_ 10k
Q2106 DN.DN Net-_Q2106-B_ GND 2N3904
R2282 Net-_Q2106-B_ GND 22k
R2281 T3 Net-_Q2106-B_ 10k
R2368 +5V QD 4.7k
Q2140 QD Net-_Q2140-B_ GND 2N3904
R2370 Net-_Q2140-B_ GND 22k
R2369 Q_N Net-_Q2140-B_ 10k
Q2141 TDQ_N Net-_Q2141-B_ Net-_Q2141-E_ 2N3904
R2373 Net-_Q2141-B_ GND 22k
Q2108 Net-_Q2107-E_ Net-_Q2108-B_ GND 2N3904
R2287 Net-_Q2108-B_ GND 22k
R2371 +5V TDQ_N 4.7k
Q2142 Net-_Q2141-E_ Net-_Q2142-B_ GND 2N3904
R2375 Net-_Q2142-B_ GND 22k
R2372 TDB Net-_Q2141-B_ 10k
R2374 QD Net-_Q2142-B_ 10k
R2097 +5V L.S2 4.7k
R2098 L.CLKB Net-_Q2036-B_ 10k
R2100 L.MQI Net-_Q2037-B_ 10k
R2099 Net-_Q2036-B_ GND 22k
Q2036 L.S2 Net-_Q2036-B_ Net-_Q2036-E_ 2N3904
Q2037 Net-_Q2036-E_ Net-_Q2037-B_ GND 2N3904
R2102 +5V L 2.2k
Q2038 L Net-_Q2038-B_ Net-_Q2038-E_ 2N3904
Q2039 Net-_Q2038-E_ Net-_Q2039-B_ GND 2N3904
R2104 Net-_Q2038-B_ GND 22k
R2105 L.QN Net-_Q2039-B_ 10k
R2103 L.S1 Net-_Q2038-B_ 10k
R2107 +5V L.QN 4.7k
R2113 L Net-_Q2042-B_ 10k
Q2040 L.QN Net-_Q2040-B_ Net-_Q2040-E_ 2N3904
Q2041 Net-_Q2040-E_ Net-_Q2041-B_ GND 2N3904
R2109 Net-_Q2040-B_ GND 22k
R2110 L.S2 Net-_Q2041-B_ 10k
R2108 L Net-_Q2040-B_ 10k
R2041 Net-_Q2013-B_ GND 22k
R2042 T1 Net-_Q2014-B_ 10k
R2044 T2 Net-_Q2015-B_ 10k
R2043 Net-_Q2014-B_ GND 22k
Q2014 BUSY_N Net-_Q2014-B_ GND 2N3904
Q2013 BUSY_N Net-_Q2013-B_ GND 2N3904
R2040 L Net-_Q2013-B_ 10k
R2127 +5V T1.M1 4.7k
R2128 L Net-_Q2047-B_ 10k
R2046 T3 Net-_Q2016-B_ 10k
R2045 Net-_Q2015-B_ GND 22k
Q2016 BUSY_N Net-_Q2016-B_ GND 2N3904
R2047 Net-_Q2016-B_ GND 22k
Q2015 BUSY_N Net-_Q2015-B_ GND 2N3904
R2048 DN Net-_Q2017-B_ 10k
Q2017 BUSY_N Net-_Q2017-B_ GND 2N3904
R2049 Net-_Q2017-B_ GND 22k
R2133 T1.CLKN Net-_Q2049-B_ 10k
R2132 +5V T1.M2 4.7k
R2051 START Net-_Q2018-B_ 10k
R2053 OP1BA Net-_Q2019-B_ 10k
R2052 Net-_Q2018-B_ GND 22k
Q2018 L_N_D Net-_Q2018-B_ Net-_Q2018-E_ 2N3904
Q2019 Net-_Q2018-E_ Net-_Q2019-B_ Net-_Q2019-E_ 2N3904
R2054 Net-_Q2019-B_ GND 22k
R2056 Net-_Q2020-B_ GND 22k
Q2020 Net-_Q2019-E_ Net-_Q2020-B_ GND 2N3904
R2055 BUSY_N Net-_Q2020-B_ 10k
R2130 T1.CLKN Net-_Q2048-B_ 10k
R2218 T2 Net-_Q2082-B_ 10k
R2220 T2.S2 Net-_Q2083-B_ 10k
R2219 Net-_Q2082-B_ GND 22k
R2129 Net-_Q2047-B_ GND 22k
R2131 Net-_Q2048-B_ GND 22k
Q2117 Net-_Q2116-E_ Net-_Q2117-B_ GND 2N3904
R2310 Net-_Q2117-B_ GND 22k
Q2149 KSEL Net-_Q2149-B_ GND 2N3904
R2394 Net-_Q2149-B_ GND 22k
R2309 DN.CLKB Net-_Q2117-B_ 10k
R2307 DN.MQ Net-_Q2116-B_ 10k
R2392 +5V KSEL 2.2k
R2393 KSEL_N Net-_Q2149-B_ 10k
R2306 +5V DN.S1 4.7k
Q2116 DN.S1 Net-_Q2116-B_ Net-_Q2116-E_ 2N3904
R2308 Net-_Q2116-B_ GND 22k
R2223 CK1 Net-_Q2084-B_ 10k
R2224 Net-_Q2084-B_ GND 22k
Q2049 T1.M2 Net-_Q2049-B_ Net-_Q2049-E_ 2N3904
R2135 T1.DN Net-_Q2050-B_ 10k
Q2047 T1.M1 Net-_Q2047-B_ Net-_Q2047-E_ 2N3904
Q2048 Net-_Q2047-E_ Net-_Q2048-B_ GND 2N3904
R2136 Net-_Q2050-B_ GND 22k
Q2050 Net-_Q2049-E_ Net-_Q2050-B_ GND 2N3904
R2134 Net-_Q2049-B_ GND 22k
R2222 +5V T3.CLKN 2.2k
Q2084 T3.CLKN Net-_Q2084-B_ GND 2N3904
R2387 +5V KSEL_N 4.7k
Q2148 KSEL_N Net-_Q2148-B_ GND 2N3904
Q2147 KSEL_N Net-_Q2147-B_ GND 2N3904
R2388 OP1NB Net-_Q2147-B_ 10k
R2390 LB Net-_Q2148-B_ 10k
R2391 Net-_Q2148-B_ GND 22k
R2389 Net-_Q2147-B_ GND 22k
R2304 DN.MQ Net-_Q2115-B_ 10k
R2305 Net-_Q2115-B_ GND 22k
Q2115 DN.MQI Net-_Q2115-B_ GND 2N3904
R2303 +5V DN.MQI 4.7k
Q2083 Net-_Q2082-E_ Net-_Q2083-B_ GND 2N3904
R2221 Net-_Q2083-B_ GND 22k
R2217 +5V T2.QN 4.7k
Q2082 T2.QN Net-_Q2082-B_ Net-_Q2082-E_ 2N3904
R2035 Net-_Q2011-B_ GND 22k
R2034 CK_N Net-_Q2011-B_ 10k
Q2011 CK1 Net-_Q2011-B_ GND 2N3904
R2033 +5V CK1 2.2k
R2030 +5V CK_N 2.2k
R2039 +5V BUSY_N 4.7k
R2050 +5V L_N_D 4.7k
R2013 OP1 Net-_Q2004-B_ 10k
R2007 OP0N Net-_Q2002-B_ 10k
R2009 +5V OP1NA 2.2k
R2006 +5V SUB2 2.2k
R2038 Net-_Q2012-B_ GND 22k
Q2012 CK2 Net-_Q2012-B_ GND 2N3904
R2037 CK_N Net-_Q2012-B_ 10k
R2032 Net-_Q2010-B_ GND 22k
R2036 +5V CK2 2.2k
R2008 Net-_Q2002-B_ GND 22k
R2067 L_D Net-_Q2024-B_ 10k
Q2024 L.DN Net-_Q2024-B_ GND 2N3904
R2068 Net-_Q2024-B_ GND 22k
R2066 +5V L.DN 4.7k
Q2023 L.CLKB Net-_Q2023-B_ GND 2N3904
R2065 Net-_Q2023-B_ GND 22k
R2063 +5V L.CLKB 4.7k
R2064 L.CLKN Net-_Q2023-B_ 10k
R2012 +5V OP1NB 2.2k
R2014 Net-_Q2004-B_ GND 22k
Q2004 OP1NB Net-_Q2004-B_ GND 2N3904
R2015 +5V OP1BA 2.2k
Q2005 OP1BA Net-_Q2005-B_ GND 2N3904
R2017 Net-_Q2005-B_ GND 22k
R2016 OP1NB Net-_Q2005-B_ 10k
R2058 L_N_D Net-_Q2021-B_ 10k
R2057 +5V L_D 4.7k
Q2021 L_D Net-_Q2021-B_ GND 2N3904
R2059 Net-_Q2021-B_ GND 22k
Q2022 L.CLKN Net-_Q2022-B_ GND 2N3904
R2062 Net-_Q2022-B_ GND 22k
R2060 +5V L.CLKN 2.2k
R2061 CK1 Net-_Q2022-B_ 10k
R2003 +5V SUB 2.2k
R2002 Net-_Q2000-B_ GND 22k
R2001 OP0 Net-_Q2000-B_ 10k
Q2010 CK_N Net-_Q2010-B_ GND 2N3904
R2031 CLOCK Net-_Q2010-B_ 10k
R2004 OP0N Net-_Q2001-B_ 10k
Q2000 OP0N Net-_Q2000-B_ GND 2N3904
R2000 +5V OP0N 2.2k
Q2001 SUB Net-_Q2001-B_ GND 2N3904
R2005 Net-_Q2001-B_ GND 22k
Q2002 SUB2 Net-_Q2002-B_ GND 2N3904
R2010 OP1 Net-_Q2003-B_ 10k
Q2003 OP1NA Net-_Q2003-B_ GND 2N3904
R2011 Net-_Q2003-B_ GND 22k
R2408 +5V AD_N0 4.7k
R2409 TDA Net-_Q2155-B_ 10k
R2411 P2 Net-_Q2156-B_ 10k
R2412 Net-_Q2156-B_ GND 22k
Q2155 AD_N0 Net-_Q2155-B_ Net-_Q2155-E_ 2N3904
R2410 Net-_Q2155-B_ GND 22k
Q2156 Net-_Q2155-E_ Net-_Q2156-B_ GND 2N3904
R2413 +5V A0 2.2k
R2414 AK_N0 Net-_Q2157-B_ 10k
R2416 AM_N0 Net-_Q2158-B_ 10k
R2415 Net-_Q2157-B_ GND 22k
Q2157 A0 Net-_Q2157-B_ Net-_Q2157-E_ 2N3904
Q2158 Net-_Q2157-E_ Net-_Q2158-B_ Net-_Q2158-E_ 2N3904
Q2159 Net-_Q2158-E_ Net-_Q2159-B_ GND 2N3904
R2419 Net-_Q2159-B_ GND 22k
R2417 Net-_Q2158-B_ GND 22k
R2418 AD_N0 Net-_Q2159-B_ 10k
R2483 +5V EB0 4.7k
Q2186 EB0 Net-_Q2186-B_ GND 2N3904
Q2185 EB0 Net-_Q2185-B_ GND 2N3904
Q2198 DIV0 Net-_Q2198-B_ GND 2N3904
R2517 Net-_Q2198-B_ GND 22k
R2487 Net-_Q2186-B_ GND 22k
R2485 Net-_Q2185-B_ GND 22k
R2484 ENCB_N0 Net-_Q2185-B_ 10k
R2486 X Net-_Q2186-B_ 10k
R2515 +5V DIV0 4.7k
R2516 DIV0_N Net-_Q2198-B_ 10k
R2493 +5V EB2 4.7k
Q2190 EB2 Net-_Q2190-B_ GND 2N3904
Q2189 EB2 Net-_Q2189-B_ GND 2N3904
R2494 ENCB_N2 Net-_Q2189-B_ 10k
R2496 X Net-_Q2190-B_ 10k
R2497 Net-_Q2190-B_ GND 22k
R2495 Net-_Q2189-B_ GND 22k
R2488 +5V EB1 4.7k
Q2188 EB1 Net-_Q2188-B_ GND 2N3904
Q2187 EB1 Net-_Q2187-B_ GND 2N3904
R2489 ENCB_N1 Net-_Q2187-B_ 10k
R2491 X Net-_Q2188-B_ 10k
R2492 Net-_Q2188-B_ GND 22k
R2490 Net-_Q2187-B_ GND 22k
R2395 +5V KA0 4.7k
R2398 +5V AK_N0 4.7k
R2400 Net-_Q2151-B_ GND 22k
Q2152 Net-_Q2151-E_ Net-_Q2152-B_ GND 2N3904
Q2151 AK_N0 Net-_Q2151-B_ Net-_Q2151-E_ 2N3904
R2399 KSEL Net-_Q2151-B_ 10k
Q2150 KA0 Net-_Q2150-B_ GND 2N3904
R2396 ENCA_N0 Net-_Q2150-B_ 10k
R2397 Net-_Q2150-B_ GND 22k
R2402 Net-_Q2152-B_ GND 22k
R2401 KA0 Net-_Q2152-B_ 10k
R2403 +5V AM_N0 4.7k
R2404 TMA Net-_Q2153-B_ 10k
R2406 P3 Net-_Q2154-B_ 10k
R2407 Net-_Q2154-B_ GND 22k
Q2153 AM_N0 Net-_Q2153-B_ Net-_Q2153-E_ 2N3904
R2405 Net-_Q2153-B_ GND 22k
Q2154 Net-_Q2153-E_ Net-_Q2154-B_ GND 2N3904
R2480 +5V X 2.2k
Q2184 X Net-_Q2184-B_ GND 2N3904
R2482 Net-_Q2184-B_ GND 22k
R2481 X_N Net-_Q2184-B_ 10k
R2473 +5V X_N 4.7k
Q2183 Net-_Q2182-E_ Net-_Q2183-B_ GND 2N3904
R2479 Net-_Q2183-B_ GND 22k
R2474 OP1BB Net-_Q2181-B_ 10k
Q2181 X_N Net-_Q2181-B_ Net-_Q2181-E_ 2N3904
R2475 Net-_Q2181-B_ GND 22k
R2476 OP0N Net-_Q2182-B_ 10k
Q2182 Net-_Q2181-E_ Net-_Q2182-B_ Net-_Q2182-E_ 2N3904
R2477 Net-_Q2182-B_ GND 22k
R2478 P0N Net-_Q2183-B_ 10k
R2470 +5V P0N 4.7k
Q2180 P0N Net-_Q2180-B_ GND 2N3904
R2472 Net-_Q2180-B_ GND 22k
R2471 P0 Net-_Q2180-B_ 10k
R2499 ENCB_N0 Net-_Q2191-B_ 10k
R2498 +5V BZ_N 4.7k
R2507 Net-_Q2194-B_ GND 22k
R2506 BZ_N Net-_Q2194-B_ 10k
R2501 ENCB_N1 Net-_Q2192-B_ 10k
R2500 Net-_Q2191-B_ GND 22k
Q2191 BZ_N Net-_Q2191-B_ Net-_Q2191-E_ 2N3904
Q2192 Net-_Q2191-E_ Net-_Q2192-B_ Net-_Q2192-E_ 2N3904
Q2194 BZ Net-_Q2194-B_ GND 2N3904
R2505 +5V BZ 4.7k
Q2195 DIV0_N Net-_Q2195-B_ Net-_Q2195-E_ 2N3904
R2510 Net-_Q2195-B_ GND 22k
Q2196 Net-_Q2195-E_ Net-_Q2196-B_ Net-_Q2196-E_ 2N3904
R2508 +5V DIV0_N 4.7k
R2509 OP1BB Net-_Q2195-B_ 10k
R2511 OP0 Net-_Q2196-B_ 10k
R2137 +5V T1.MQ 4.7k
R2141 Net-_Q2052-B_ GND 22k
R2138 T1.M1 Net-_Q2051-B_ 10k
R2140 T1.MQN Net-_Q2052-B_ 10k
Q2051 T1.MQ Net-_Q2051-B_ Net-_Q2051-E_ 2N3904
R2139 Net-_Q2051-B_ GND 22k
Q2052 Net-_Q2051-E_ Net-_Q2052-B_ GND 2N3904
Q2122 DN.QN Net-_Q2122-B_ Net-_Q2122-E_ 2N3904
R2323 Net-_Q2122-B_ GND 22k
R2321 +5V DN.QN 4.7k
Q2123 Net-_Q2122-E_ Net-_Q2123-B_ GND 2N3904
R2325 Net-_Q2123-B_ GND 22k
R2322 DN Net-_Q2122-B_ 10k
R2324 DN.S2 Net-_Q2123-B_ 10k
Q2088 Net-_Q2087-E_ Net-_Q2088-B_ GND 2N3904
R2235 Net-_Q2088-B_ GND 22k
R2142 +5V T1.MQN 4.7k
R2143 T1.MQ Net-_Q2053-B_ 10k
R2145 T1.M2 Net-_Q2054-B_ 10k
Q2054 Net-_Q2053-E_ Net-_Q2054-B_ GND 2N3904
Q2053 T1.MQN Net-_Q2053-B_ Net-_Q2053-E_ 2N3904
R2144 Net-_Q2053-B_ GND 22k
R2146 Net-_Q2054-B_ GND 22k
R2232 T2 Net-_Q2087-B_ 10k
R2234 T3.CLKN Net-_Q2088-B_ 10k
R2231 +5V T3.M1 4.7k
Q2055 T1.MQI Net-_Q2055-B_ GND 2N3904
R2149 Net-_Q2055-B_ GND 22k
Q2087 T3.M1 Net-_Q2087-B_ Net-_Q2087-E_ 2N3904
R2233 Net-_Q2087-B_ GND 22k
R2147 +5V T1.MQI 4.7k
R2148 T1.MQ Net-_Q2055-B_ 10k
R2316 +5V DN 4.7k
R2317 DN.S1 Net-_Q2120-B_ 10k
R2319 DN.QN Net-_Q2121-B_ 10k
Q2120 DN Net-_Q2120-B_ Net-_Q2120-E_ 2N3904
Q2121 Net-_Q2120-E_ Net-_Q2121-B_ GND 2N3904
R2320 Net-_Q2121-B_ GND 22k
R2318 Net-_Q2120-B_ GND 22k
R2228 +5V T3.DN 4.7k
Q2086 T3.DN Net-_Q2086-B_ GND 2N3904
R2230 Net-_Q2086-B_ GND 22k
R2229 T2 Net-_Q2086-B_ 10k
R2225 +5V T3.CLKB 4.7k
Q2085 T3.CLKB Net-_Q2085-B_ GND 2N3904
R2226 T3.CLKN Net-_Q2085-B_ 10k
R2227 Net-_Q2085-B_ GND 22k
R2311 +5V DN.S2 4.7k
Q2118 DN.S2 Net-_Q2118-B_ Net-_Q2118-E_ 2N3904
R2314 DN.MQI Net-_Q2119-B_ 10k
R2312 DN.CLKB Net-_Q2118-B_ 10k
R2313 Net-_Q2118-B_ GND 22k
Q2119 Net-_Q2118-E_ Net-_Q2119-B_ GND 2N3904
R2315 Net-_Q2119-B_ GND 22k
R3227 +5V MEMCLK 2.2k
R3229 Net-_Q2478-B_ GND 22k
Q2478 MEMCLK Net-_Q2478-B_ GND 2N3904
Q2479 MEMCLK2 Net-_Q2479-B_ GND 2N3904
R3232 Net-_Q2479-B_ GND 22k
R3230 +5V MEMCLK2 4.7k
R3231 MEMCLK_N Net-_Q2479-B_ 10k
R3222 +5V MEMCLK_N 4.7k
Q2476 MEMCLK_N Net-_Q2476-B_ Net-_Q2476-E_ 2N3904
R3223 CK1 Net-_Q2476-B_ 10k
R3225 ENL Net-_Q2477-B_ 10k
Q2477 Net-_Q2476-E_ Net-_Q2477-B_ GND 2N3904
R3226 Net-_Q2477-B_ GND 22k
R3224 Net-_Q2476-B_ GND 22k
R3228 MEMCLK_N Net-_Q2478-B_ 10k
R3212 +5V ENL 4.7k
R3213 G1 Net-_Q2472-B_ 10k
R3215 ENLN Net-_Q2473-B_ 10k
R3216 Net-_Q2473-B_ GND 22k
Q2472 ENL Net-_Q2472-B_ Net-_Q2472-E_ 2N3904
R3214 Net-_Q2472-B_ GND 22k
Q2473 Net-_Q2472-E_ Net-_Q2473-B_ GND 2N3904
R3217 +5V ENLN 4.7k
R3218 ENL Net-_Q2474-B_ 10k
R3220 G2 Net-_Q2475-B_ 10k
R3221 Net-_Q2475-B_ GND 22k
Q2474 ENLN Net-_Q2474-B_ Net-_Q2474-E_ 2N3904
R3219 Net-_Q2474-B_ GND 22k
Q2475 Net-_Q2474-E_ Net-_Q2475-B_ GND 2N3904
Q2435 Net-_Q2434-E_ Net-_Q2435-B_ GND 2N3904
R3118 Net-_Q2435-B_ GND 22k
R3114 +5V OUT_B4.MQN 4.7k
R3116 Net-_Q2434-B_ GND 22k
Q2434 OUT_B4.MQN Net-_Q2434-B_ Net-_Q2434-E_ 2N3904
R3115 OUT_B4.MQ Net-_Q2434-B_ 10k
R3117 OUT_B4.M2 Net-_Q2435-B_ 10k
R3014 +5V REG_D0 4.7k
R3015 RD_A0 Net-_Q2395-B_ 10k
R3017 RD_M0 Net-_Q2396-B_ 10k
R3020 OP1NA Net-_Q2397-B_ 10k
R3022 OUT1 Net-_Q2398-B_ 10k
Q2396 Net-_Q2395-E_ Net-_Q2396-B_ GND 2N3904
Q2395 REG_D0 Net-_Q2395-B_ Net-_Q2395-E_ 2N3904
R3016 Net-_Q2395-B_ GND 22k
R3029 +5V REG_D1 4.7k
R3120 OUT_B4.MQ Net-_Q2436-B_ 10k
R3030 RD_A1 Net-_Q2401-B_ 10k
R3032 RD_M1 Net-_Q2402-B_ 10k
Q2401 REG_D1 Net-_Q2401-B_ Net-_Q2401-E_ 2N3904
R3031 Net-_Q2401-B_ GND 22k
Q2402 Net-_Q2401-E_ Net-_Q2402-B_ GND 2N3904
R3033 Net-_Q2402-B_ GND 22k
R3119 +5V OUT_B4.MQI 4.7k
Q2436 OUT_B4.MQI Net-_Q2436-B_ GND 2N3904
R3121 Net-_Q2436-B_ GND 22k
R3024 +5V RD_M1 4.7k
Q2399 RD_M1 Net-_Q2399-B_ Net-_Q2399-E_ 2N3904
R3025 OP1BA Net-_Q2399-B_ 10k
Q2400 Net-_Q2399-E_ Net-_Q2400-B_ GND 2N3904
R3026 Net-_Q2399-B_ GND 22k
R3028 Net-_Q2400-B_ GND 22k
R3027 P1 Net-_Q2400-B_ 10k
R3019 +5V RD_A1 4.7k
R3021 Net-_Q2397-B_ GND 22k
Q2397 RD_A1 Net-_Q2397-B_ Net-_Q2397-E_ 2N3904
R3023 Net-_Q2398-B_ GND 22k
Q2398 Net-_Q2397-E_ Net-_Q2398-B_ GND 2N3904
R3018 Net-_Q2396-B_ GND 22k
R3104 +5V OUT_B4.M2 4.7k
R3108 Net-_Q2431-B_ GND 22k
Q2431 Net-_Q2430-E_ Net-_Q2431-B_ GND 2N3904
R3107 OUT_B4.DN Net-_Q2431-B_ 10k
Q2430 OUT_B4.M2 Net-_Q2430-B_ Net-_Q2430-E_ 2N3904
R3105 OUT_B4.CLKN Net-_Q2430-B_ 10k
R3106 Net-_Q2430-B_ GND 22k
R3110 OUT_B4.M1 Net-_Q2432-B_ 10k
R3112 OUT_B4.MQN Net-_Q2433-B_ 10k
Q2432 OUT_B4.MQ Net-_Q2432-B_ Net-_Q2432-E_ 2N3904
R3111 Net-_Q2432-B_ GND 22k
R3113 Net-_Q2433-B_ GND 22k
Q2433 Net-_Q2432-E_ Net-_Q2433-B_ GND 2N3904
R3109 +5V OUT_B4.MQ 4.7k
Q2441 OUT_B4 Net-_Q2441-B_ Net-_Q2441-E_ 2N3904
R3133 OUT_B4.S1 Net-_Q2441-B_ 10k
R3134 Net-_Q2441-B_ GND 22k
R3132 +5V OUT_B4 2.2k
R3135 OUT_B4.QN Net-_Q2442-B_ 10k
Q2442 Net-_Q2441-E_ Net-_Q2442-B_ GND 2N3904
R3136 Net-_Q2442-B_ GND 22k
R3042 P2 Net-_Q2406-B_ 10k
Q2406 Net-_Q2405-E_ Net-_Q2406-B_ GND 2N3904
R3043 Net-_Q2406-B_ GND 22k
Q2408 Net-_Q2407-E_ Net-_Q2408-B_ GND 2N3904
R3048 Net-_Q2408-B_ GND 22k
Q2407 REG_D2 Net-_Q2407-B_ Net-_Q2407-E_ 2N3904
R3047 RD_M2 Net-_Q2408-B_ 10k
R3045 RD_A2 Net-_Q2407-B_ 10k
R3044 +5V REG_D2 4.7k
R3046 Net-_Q2407-B_ GND 22k
R3041 Net-_Q2405-B_ GND 22k
R3039 +5V RD_M2 4.7k
Q2405 RD_M2 Net-_Q2405-B_ Net-_Q2405-E_ 2N3904
R3040 OP1BA Net-_Q2405-B_ 10k
R3126 Net-_Q2438-B_ GND 22k
Q2438 Net-_Q2437-E_ Net-_Q2438-B_ GND 2N3904
R3035 OP1NA Net-_Q2403-B_ 10k
R3037 OUT2 Net-_Q2404-B_ 10k
Q2437 OUT_B4.S1 Net-_Q2437-B_ Net-_Q2437-E_ 2N3904
R3124 Net-_Q2437-B_ GND 22k
R3122 +5V OUT_B4.S1 4.7k
R3123 OUT_B4.MQ Net-_Q2437-B_ 10k
R3125 OUT_B4.CLKB Net-_Q2438-B_ 10k
R3130 OUT_B4.MQI Net-_Q2440-B_ 10k
R3128 OUT_B4.CLKB Net-_Q2439-B_ 10k
Q2439 OUT_B4.S2 Net-_Q2439-B_ Net-_Q2439-E_ 2N3904
R3127 +5V OUT_B4.S2 4.7k
R3129 Net-_Q2439-B_ GND 22k
Q2440 Net-_Q2439-E_ Net-_Q2440-B_ GND 2N3904
R3131 Net-_Q2440-B_ GND 22k
R3038 Net-_Q2404-B_ GND 22k
Q2404 Net-_Q2403-E_ Net-_Q2404-B_ GND 2N3904
Q2403 RD_A2 Net-_Q2403-B_ Net-_Q2403-E_ 2N3904
R3036 Net-_Q2403-B_ GND 22k
R3034 +5V RD_A2 4.7k
Q2461 OUT_B5 Net-_Q2461-B_ Net-_Q2461-E_ 2N3904
R3185 OUT_B5.S1 Net-_Q2461-B_ 10k
R3187 OUT_B5.QN Net-_Q2462-B_ 10k
Q2462 Net-_Q2461-E_ Net-_Q2462-B_ GND 2N3904
R3188 Net-_Q2462-B_ GND 22k
R3186 Net-_Q2461-B_ GND 22k
Q2463 OUT_B5.QN Net-_Q2463-B_ Net-_Q2463-E_ 2N3904
R3191 Net-_Q2463-B_ GND 22k
R3193 Net-_Q2464-B_ GND 22k
Q2464 Net-_Q2463-E_ Net-_Q2464-B_ GND 2N3904
R3190 OUT_B5 Net-_Q2463-B_ 10k
R3192 OUT_B5.S2 Net-_Q2464-B_ 10k
R3200 EN_N Net-_Q2467-B_ 10k
R3201 Net-_Q2467-B_ GND 22k
Q2467 EN Net-_Q2467-B_ GND 2N3904
Q2465 EN_N Net-_Q2465-B_ GND 2N3904
R3196 Net-_Q2465-B_ GND 22k
R3198 Net-_Q2466-B_ GND 22k
Q2466 EN_N Net-_Q2466-B_ GND 2N3904
R3203 EN Net-_Q2468-B_ 10k
R3205 CK_N Net-_Q2469-B_ 10k
R3197 DN Net-_Q2466-B_ 10k
R3195 OP1NB Net-_Q2465-B_ 10k
R3199 +5V EN 4.7k
R3194 +5V EN_N 4.7k
R3010 OP1BA Net-_Q2393-B_ 10k
R3012 P0 Net-_Q2394-B_ 10k
R3009 +5V RD_M0 4.7k
R3004 +5V RD_A0 4.7k
Q2393 RD_M0 Net-_Q2393-B_ Net-_Q2393-E_ 2N3904
R3011 Net-_Q2393-B_ GND 22k
Q2391 RD_A0 Net-_Q2391-B_ Net-_Q2391-E_ 2N3904
R3006 Net-_Q2391-B_ GND 22k
R3005 OP1NA Net-_Q2391-B_ 10k
R3007 OUT0 Net-_Q2392-B_ 10k
Q2469 Net-_Q2468-E_ Net-_Q2469-B_ GND 2N3904
R3206 Net-_Q2469-B_ GND 22k
R3207 +5V G2 4.7k
R3210 CK_N Net-_Q2471-B_ 10k
R3211 Net-_Q2471-B_ GND 22k
Q2470 G2 Net-_Q2470-B_ Net-_Q2470-E_ 2N3904
R3209 Net-_Q2470-B_ GND 22k
Q2471 Net-_Q2470-E_ Net-_Q2471-B_ GND 2N3904
R3208 EN_N Net-_Q2470-B_ 10k
R3202 +5V G1 4.7k
Q2468 G1 Net-_Q2468-B_ Net-_Q2468-E_ 2N3904
R3204 Net-_Q2468-B_ GND 22k
Q2427 OUT_B4.DN Net-_Q2427-B_ GND 2N3904
R3098 Net-_Q2427-B_ GND 22k
R3097 D4 Net-_Q2427-B_ 10k
Q2429 Net-_Q2428-E_ Net-_Q2429-B_ GND 2N3904
R3103 Net-_Q2429-B_ GND 22k
R3184 +5V OUT_B5 2.2k
R3101 Net-_Q2428-B_ GND 22k
R3100 D4 Net-_Q2428-B_ 10k
R3102 OUT_B4.CLKN Net-_Q2429-B_ 10k
Q2428 OUT_B4.M1 Net-_Q2428-B_ Net-_Q2428-E_ 2N3904
R3189 +5V OUT_B5.QN 4.7k
R3099 +5V OUT_B4.M1 4.7k
Q2394 Net-_Q2393-E_ Net-_Q2394-B_ GND 2N3904
R3013 Net-_Q2394-B_ GND 22k
Q2392 Net-_Q2391-E_ Net-_Q2392-B_ GND 2N3904
R3096 +5V OUT_B4.DN 4.7k
R3008 Net-_Q2392-B_ GND 22k
V103 X1 GND PWL( 0 0 0.000409 0 0.000411 0 0.000709 0 0.000711 0 0.001009 0 0.001011 0 0.001309 0 0.001311 0 0.001609 0 0.001611 0 0.001909 0 0.001911 0 0.002609 0 0.002611 0 0.003309 0 0.003311 0 0.004009 0 0.004011 0 0.004709 0 0.004711 0 0.005409 0 0.005411 0 0.006109 0 0.006111 0 0.006809 0 0.006811 5 0.007509 5 0.007511 0 0.008209 0 0.008211 0 0.008509 0 0.008511 0 )
V104 Y2 GND PWL( 0 0 0.000409 0 0.000411 0 0.000709 0 0.000711 0 0.001009 0 0.001011 0 0.001309 0 0.001311 5 0.001609 5 0.001611 0 0.001909 0 0.001911 0 0.002609 0 0.002611 0 0.003309 0 0.003311 0 0.004009 0 0.004011 0 0.004709 0 0.004711 0 0.005409 0 0.005411 0 0.006109 0 0.006111 0 0.006809 0 0.006811 0 0.007509 0 0.007511 0 0.008209 0 0.008211 0 0.008509 0 0.008511 0 )
V102 Y1 GND PWL( 0 0 0.000409 0 0.000411 0 0.000709 0 0.000711 0 0.001009 0 0.001011 0 0.001309 0 0.001311 0 0.001609 0 0.001611 0 0.001909 0 0.001911 0 0.002609 0 0.002611 0 0.003309 0 0.003311 0 0.004009 0 0.004011 5 0.004709 5 0.004711 0 0.005409 0 0.005411 0 0.006109 0 0.006111 0 0.006809 0 0.006811 0 0.007509 0 0.007511 0 0.008209 0 0.008211 0 0.008509 0 0.008511 0 )
V106 Y3 GND PWL( 0 0 0.000409 0 0.000411 5 0.000709 5 0.000711 0 0.001009 0 0.001011 0 0.001309 0 0.001311 0 0.001609 0 0.001611 0 0.001909 0 0.001911 5 0.002609 5 0.002611 0 0.003309 0 0.003311 0 0.004009 0 0.004011 0 0.004709 0 0.004711 0 0.005409 0 0.005411 0 0.006109 0 0.006111 0 0.006809 0 0.006811 0 0.007509 0 0.007511 0 0.008209 0 0.008211 0 0.008509 0 0.008511 0 )
V105 X2 GND PWL( 0 0 0.000409 0 0.000411 0 0.000709 0 0.000711 0 0.001009 0 0.001011 0 0.001309 0 0.001311 0 0.001609 0 0.001611 0 0.001909 0 0.001911 0 0.002609 0 0.002611 0 0.003309 0 0.003311 0 0.004009 0 0.004011 0 0.004709 0 0.004711 5 0.005409 5 0.005411 0 0.006109 0 0.006111 0 0.006809 0 0.006811 0 0.007509 0 0.007511 0 0.008209 0 0.008211 0 0.008509 0 0.008511 0 )
V101 CLOCK GND PULSE( 0 5 25u 1u 1u 49u 0.0001 )
V107 X3 GND PWL( 0 0 0.000409 0 0.000411 0 0.000709 0 0.000711 0 0.001009 0 0.001011 0 0.001309 0 0.001311 0 0.001609 0 0.001611 0 0.001909 0 0.001911 0 0.002609 0 0.002611 0 0.003309 0 0.003311 0 0.004009 0 0.004011 0 0.004709 0 0.004711 0 0.005409 0 0.005411 5 0.006109 5 0.006111 0 0.006809 0 0.006811 0 0.007509 0 0.007511 0 0.008209 0 0.008211 0 0.008509 0 0.008511 0 )
V111 X5 GND PWL( 0 0 0.000409 0 0.000411 0 0.000709 0 0.000711 0 0.001009 0 0.001011 5 0.001309 5 0.001311 5 0.001609 5 0.001611 0 0.001909 0 0.001911 5 0.002609 5 0.002611 0 0.003309 0 0.003311 0 0.004009 0 0.004011 0 0.004709 0 0.004711 0 0.005409 0 0.005411 0 0.006109 0 0.006111 0 0.006809 0 0.006811 0 0.007509 0 0.007511 0 0.008209 0 0.008211 0 0.008509 0 0.008511 5 )
V109 X4 GND PWL( 0 0 0.000409 0 0.000411 5 0.000709 5 0.000711 0 0.001009 0 0.001011 0 0.001309 0 0.001311 0 0.001609 0 0.001611 0 0.001909 0 0.001911 0 0.002609 0 0.002611 0 0.003309 0 0.003311 0 0.004009 0 0.004011 0 0.004709 0 0.004711 0 0.005409 0 0.005411 0 0.006109 0 0.006111 0 0.006809 0 0.006811 0 0.007509 0 0.007511 0 0.008209 0 0.008211 0 0.008509 0 0.008511 0 )
V110 Y5 GND PWL( 0 0 0.000409 0 0.000411 0 0.000709 0 0.000711 0 0.001009 0 0.001011 0 0.001309 0 0.001311 0 0.001609 0 0.001611 0 0.001909 0 0.001911 0 0.002609 0 0.002611 0 0.003309 0 0.003311 0 0.004009 0 0.004011 0 0.004709 0 0.004711 0 0.005409 0 0.005411 0 0.006109 0 0.006111 5 0.006809 5 0.006811 0 0.007509 0 0.007511 0 0.008209 0 0.008211 0 0.008509 0 0.008511 5 )
V108 Y4 GND PWL( 0 0 0.000409 0 0.000411 0 0.000709 0 0.000711 0 0.001009 0 0.001011 0 0.001309 0 0.001311 0 0.001609 0 0.001611 0 0.001909 0 0.001911 0 0.002609 0 0.002611 0 0.003309 0 0.003311 0 0.004009 0 0.004011 0 0.004709 0 0.004711 0 0.005409 0 0.005411 0 0.006109 0 0.006111 0 0.006809 0 0.006811 0 0.007509 0 0.007511 5 0.008209 5 0.008211 0 0.008509 0 0.008511 0 )
V112 Y6 GND PWL( 0 0 0.000409 0 0.000411 0 0.000709 0 0.000711 0 0.001009 0 0.001011 0 0.001309 0 0.001311 0 0.001609 0 0.001611 0 0.001909 0 0.001911 0 0.002609 0 0.002611 0 0.003309 0 0.003311 5 0.004009 5 0.004011 0 0.004709 0 0.004711 0 0.005409 0 0.005411 5 0.006109 5 0.006111 0 0.006809 0 0.006811 0 0.007509 0 0.007511 0 0.008209 0 0.008211 5 0.008509 5 0.008511 0 )
V116 OP0 GND PWL( 0 0 0.000409 0 0.000411 0 0.000709 0 0.000711 0 0.001009 0 0.001011 5 0.001309 5 0.001311 5 0.001609 5 0.001611 0 0.001909 0 0.001911 0 0.002609 0 0.002611 0 0.003309 0 0.003311 0 0.004009 0 0.004011 0 0.004709 0 0.004711 5 0.005409 5 0.005411 5 0.006109 5 0.006111 5 0.006809 5 0.006811 5 0.007509 5 0.007511 5 0.008209 5 0.008211 5 0.008509 5 0.008511 0 )
V117 OP1 GND PWL( 0 0 0.000409 0 0.000411 0 0.000709 0 0.000711 0 0.001009 0 0.001011 0 0.001309 0 0.001311 0 0.001609 0 0.001611 0 0.001909 0 0.001911 5 0.002609 5 0.002611 5 0.003309 5 0.003311 5 0.004009 5 0.004011 5 0.004709 5 0.004711 5 0.005409 5 0.005411 5 0.006109 5 0.006111 5 0.006809 5 0.006811 5 0.007509 5 0.007511 5 0.008209 5 0.008211 0 0.008509 0 0.008511 5 )
V114 Y7 GND PWL( 0 0 0.000409 0 0.000411 0 0.000709 0 0.000711 5 0.001009 5 0.001011 5 0.001309 5 0.001311 0 0.001609 0 0.001611 0 0.001909 0 0.001911 0 0.002609 0 0.002611 5 0.003309 5 0.003311 0 0.004009 0 0.004011 0 0.004709 0 0.004711 5 0.005409 5 0.005411 0 0.006109 0 0.006111 0 0.006809 0 0.006811 5 0.007509 5 0.007511 0 0.008209 0 0.008211 0 0.008509 0 0.008511 0 )
V115 X7 GND PWL( 0 0 0.000409 0 0.000411 0 0.000709 0 0.000711 5 0.001009 5 0.001011 0 0.001309 0 0.001311 0 0.001609 0 0.001611 0 0.001909 0 0.001911 0 0.002609 0 0.002611 5 0.003309 5 0.003311 0 0.004009 0 0.004011 5 0.004709 5 0.004711 0 0.005409 0 0.005411 0 0.006109 0 0.006111 5 0.006809 5 0.006811 0 0.007509 0 0.007511 0 0.008209 0 0.008211 0 0.008509 0 0.008511 0 )
V118 START GND PWL( 0 0 0.000409 0 0.000411 0 0.000709 0 0.000711 0 0.001009 0 0.001011 0 0.001309 0 0.001311 0 0.001609 0 0.001611 0 0.001909 0 0.001911 5 0.002009 5 0.002011 0 0.002609 0 0.002611 5 0.002709 5 0.002711 0 0.003309 0 0.003311 5 0.003409 5 0.003411 0 0.004009 0 0.004011 5 0.004109 5 0.004111 0 0.004709 0 0.004711 5 0.004809 5 0.004811 0 0.005409 0 0.005411 5 0.005509 5 0.005511 0 0.006109 0 0.006111 5 0.006209 5 0.006211 0 0.006809 0 0.006811 5 0.006909 5 0.006911 0 0.007509 0 0.007511 5 0.007609 5 0.007611 0 0.008209 0 0.008211 0 0.008509 0 0.008511 5 0.008609 5 0.008611 0 )
V113 X6 GND PWL( 0 0 0.000409 0 0.000411 0 0.000709 0 0.000711 0 0.001009 0 0.001011 0 0.001309 0 0.001311 0 0.001609 0 0.001611 5 0.001909 5 0.001911 0 0.002609 0 0.002611 0 0.003309 0 0.003311 0 0.004009 0 0.004011 0 0.004709 0 0.004711 0 0.005409 0 0.005411 0 0.006109 0 0.006111 0 0.006809 0 0.006811 0 0.007509 0 0.007511 0 0.008209 0 0.008211 5 0.008509 5 0.008511 0 )
.end
